 // Design library name: TSMC22ULL_Std_AMP_LIB
 // Design cell name: TB_TRANR2R_SMCNR_PNin_2
 simulator lang=spectre
 global 0
 parameters RESISTOR_0=0.08k MOSFET_15_1_L_EXTCM_NMOS=0.08u MOSFET_15_1_M_EXTCM_NMOS=30.0 MOSFET_15_1_W_EXTCM_NMOS=1.0u MOSFET_16_1_L_EXTCM_PMOS=0.85u MOSFET_16_1_M_EXTCM_PMOS=30.0 MOSFET_16_1_W_EXTCM_PMOS=1.0u MOSFET_0_8_L_BIASCM_PMOS=0.48u MOSFET_0_8_M_BIASCM_PMOS=30.0 MOSFET_0_8_W_BIASCM_PMOS=1.0u MOSFET_17_7_L_BIASCM_NMOS=0.1698321u MOSFET_17_7_M_BIASCM_NMOS=8.0 MOSFET_17_7_W_BIASCM_NMOS=0.8874819u MOSFET_19_7_L_gm1_NMOS=0.08u MOSFET_19_7_M_gm1_NMOS=30.0 MOSFET_19_7_W_gm1_NMOS=0.9225152u MOSFET_28_1_L_gm2_PMOS=0.105309u MOSFET_28_1_M_gm2_PMOS=30.0 MOSFET_28_1_W_gm2_PMOS=1.0u MOSFET_29_1_L_gm2_NMOS=0.04u MOSFET_29_1_M_gm2_NMOS=30.0 MOSFET_29_1_W_gm2_NMOS=1.0u MOSFET_4_1_L_gm1_PMOS=0.04u MOSFET_4_1_M_gm1_PMOS=1.0 MOSFET_4_1_W_gm1_PMOS=0.5928191u CAPACITOR_0=0.183579p CURRENT_0_BIAS=17.4111u CLOAD=1p VCM=0.3 VDD=0.81
 include "/home/soc/zhihc21/7_Amp_complier/OTA_Compiler_251229/Process_Library/22nm_0p9V/models/crn22ull_1d8_elk_v1d3_1p1_shrink0d855_embedded_usage.scs" section=SSMacro_MOS_MOSCAP
include "/home/soc/zhihc21/7_Amp_complier/OTA_Compiler_251229/Process_Library/22nm_0p9V/models/crn22ull_1d8_elk_v1d3_1p1_shrink0d855_embedded_usage.scs" section=pre_simu
// Library name: TSMC22ULL_Std_AMP_LIB
 // Cell name: R2R_SMCNR_PNin_2
 // View name: schematic
 subckt R2R_SMCNR_PNin_2 GNDA VDDA VINN VINP VOUT
     I0 (VB1 GNDA) isource dc=CURRENT_0_BIAS type=dc
     R0 (net4 VOUT) resistor r=RESISTOR_0
     R1 (net16 VOUT) resistor r=RESISTOR_0
     M44 (net12 VB4 GNDA GNDA) nch_ulvt_mac l=MOSFET_17_7_L_BIASCM_NMOS w=MOSFET_17_7_W_BIASCM_NMOS*1 multi=MOSFET_17_7_M_BIASCM_NMOS*2 nf=1
     M28 (net10 net10 net11 GNDA) nch_ulvt_mac l=MOSFET_29_1_L_gm2_NMOS w=MOSFET_29_1_W_gm2_NMOS*1 multi=MOSFET_29_1_M_gm2_NMOS nf=1
     M26 (net2 net10 net1 GNDA) nch_ulvt_mac l=MOSFET_29_1_L_gm2_NMOS w=MOSFET_29_1_W_gm2_NMOS*1 multi=MOSFET_29_1_M_gm2_NMOS nf=1
     M29 (VOUT net1 GNDA GNDA) nch_ulvt_mac l=MOSFET_29_1_L_gm2_NMOS w=MOSFET_29_1_W_gm2_NMOS*1 multi=MOSFET_29_1_M_gm2_NMOS*10 nf=1
     M46 (net7 VB3 net3 GNDA) nch_ulvt_mac l=MOSFET_17_7_L_BIASCM_NMOS w=MOSFET_17_7_W_BIASCM_NMOS*1 multi=MOSFET_17_7_M_BIASCM_NMOS*8 nf=1
     M47 (net1 VB3 net8 GNDA) nch_ulvt_mac l=MOSFET_17_7_L_BIASCM_NMOS w=MOSFET_17_7_W_BIASCM_NMOS*1 multi=MOSFET_17_7_M_BIASCM_NMOS*8 nf=1
     M24 (net11 net11 GNDA GNDA) nch_ulvt_mac l=MOSFET_29_1_L_gm2_NMOS w=MOSFET_29_1_W_gm2_NMOS*1 multi=MOSFET_29_1_M_gm2_NMOS nf=1
     M39 (net3 net7 GNDA GNDA) nch_ulvt_mac l=MOSFET_17_7_L_BIASCM_NMOS w=MOSFET_17_7_W_BIASCM_NMOS*1 multi=MOSFET_17_7_M_BIASCM_NMOS*16 nf=1
     M40 (net8 net7 GNDA GNDA) nch_ulvt_mac l=MOSFET_17_7_L_BIASCM_NMOS w=MOSFET_17_7_W_BIASCM_NMOS*1 multi=MOSFET_17_7_M_BIASCM_NMOS*16 nf=1
     M33 (net17 net10 net7 GNDA) nch_ulvt_mac l=MOSFET_29_1_L_gm2_NMOS w=MOSFET_29_1_W_gm2_NMOS*1 multi=MOSFET_29_1_M_gm2_NMOS*2 nf=1
     M22 (net19 VB4 GNDA GNDA) nch_ulvt_mac l=MOSFET_17_7_L_BIASCM_NMOS w=MOSFET_17_7_W_BIASCM_NMOS*1 multi=MOSFET_17_7_M_BIASCM_NMOS*8 nf=1
     M20 (net5 VINP net19 GNDA) nch_ulvt_mac l=MOSFET_19_7_L_gm1_NMOS w=MOSFET_19_7_W_gm1_NMOS*1 multi=MOSFET_19_7_M_gm1_NMOS nf=1
     M19 (net6 VINN net19 GNDA) nch_ulvt_mac l=MOSFET_19_7_L_gm1_NMOS w=MOSFET_19_7_W_gm1_NMOS*1 multi=MOSFET_19_7_M_gm1_NMOS nf=1
     M14 (VB3 VB3 GNDA GNDA) nch_ulvt_mac l=MOSFET_17_7_L_BIASCM_NMOS w=MOSFET_17_7_W_BIASCM_NMOS*1 multi=MOSFET_17_7_M_BIASCM_NMOS nf=1
     M12 (VB4 VB3 net35 GNDA) nch_ulvt_mac l=MOSFET_17_7_L_BIASCM_NMOS w=MOSFET_17_7_W_BIASCM_NMOS*1 multi=MOSFET_17_7_M_BIASCM_NMOS*4 nf=1
     M13 (net78 VB3 net79 GNDA) nch_ulvt_mac l=MOSFET_17_7_L_BIASCM_NMOS w=MOSFET_17_7_W_BIASCM_NMOS*1 multi=MOSFET_17_7_M_BIASCM_NMOS*4 nf=1
     M63 (VB2 VB3 net80 GNDA) nch_ulvt_mac l=MOSFET_17_7_L_BIASCM_NMOS w=MOSFET_17_7_W_BIASCM_NMOS*1 multi=MOSFET_17_7_M_BIASCM_NMOS*4 nf=1
     M15 (net14 VB3 net19 GNDA) nch_ulvt_mac l=MOSFET_15_1_L_EXTCM_NMOS w=MOSFET_15_1_W_EXTCM_NMOS*1 multi=MOSFET_15_1_M_EXTCM_NMOS nf=1
     M11 (net19 net15 GNDA GNDA) nch_ulvt_mac l=MOSFET_17_7_L_BIASCM_NMOS w=MOSFET_17_7_W_BIASCM_NMOS*1 multi=MOSFET_17_7_M_BIASCM_NMOS*12 nf=1
     M10 (net15 net15 GNDA GNDA) nch_ulvt_mac l=MOSFET_17_7_L_BIASCM_NMOS w=MOSFET_17_7_W_BIASCM_NMOS*1 multi=MOSFET_17_7_M_BIASCM_NMOS*4 nf=1
     M17 (net35 VB4 GNDA GNDA) nch_ulvt_mac l=MOSFET_17_7_L_BIASCM_NMOS w=MOSFET_17_7_W_BIASCM_NMOS*1 multi=MOSFET_17_7_M_BIASCM_NMOS*4 nf=1
     M18 (net79 VB4 GNDA GNDA) nch_ulvt_mac l=MOSFET_17_7_L_BIASCM_NMOS w=MOSFET_17_7_W_BIASCM_NMOS*1 multi=MOSFET_17_7_M_BIASCM_NMOS*4 nf=1
     M64 (net80 VB4 GNDA GNDA) nch_ulvt_mac l=MOSFET_17_7_L_BIASCM_NMOS w=MOSFET_17_7_W_BIASCM_NMOS*1 multi=MOSFET_17_7_M_BIASCM_NMOS*4 nf=1
     M45 (net7 net12 net17 VDDA) pch_ulvt_mac l=MOSFET_28_1_L_gm2_PMOS w=MOSFET_28_1_W_gm2_PMOS*1 multi=MOSFET_28_1_M_gm2_PMOS*2 nf=1
     M38 (net13 net13 VDDA VDDA) pch_ulvt_mac l=MOSFET_28_1_L_gm2_PMOS w=MOSFET_28_1_W_gm2_PMOS*1 multi=MOSFET_28_1_M_gm2_PMOS nf=1
     M48 (net5 net17 VDDA VDDA) pch_ulvt_mac l=MOSFET_0_8_L_BIASCM_PMOS w=MOSFET_0_8_W_BIASCM_PMOS*1 multi=MOSFET_0_8_M_BIASCM_PMOS*16 nf=1
     M49 (net6 net17 VDDA VDDA) pch_ulvt_mac l=MOSFET_0_8_L_BIASCM_PMOS w=MOSFET_0_8_W_BIASCM_PMOS*1 multi=MOSFET_0_8_M_BIASCM_PMOS*16 nf=1
     M43 (net17 VB2 net6 VDDA) pch_ulvt_mac l=MOSFET_0_8_L_BIASCM_PMOS w=MOSFET_0_8_W_BIASCM_PMOS*1 multi=MOSFET_0_8_M_BIASCM_PMOS*8 nf=1
     M42 (net2 VB2 net5 VDDA) pch_ulvt_mac l=MOSFET_0_8_L_BIASCM_PMOS w=MOSFET_0_8_W_BIASCM_PMOS*1 multi=MOSFET_0_8_M_BIASCM_PMOS*8 nf=1
     M32 (VOUT net2 VDDA VDDA) pch_ulvt_mac l=MOSFET_28_1_L_gm2_PMOS w=MOSFET_28_1_W_gm2_PMOS*1 multi=MOSFET_28_1_M_gm2_PMOS*10 nf=1
     M31 (net12 net12 net13 VDDA) pch_ulvt_mac l=MOSFET_28_1_L_gm2_PMOS w=MOSFET_28_1_W_gm2_PMOS*1 multi=MOSFET_28_1_M_gm2_PMOS nf=1
     M30 (net1 net12 net2 VDDA) pch_ulvt_mac l=MOSFET_28_1_L_gm2_PMOS w=MOSFET_28_1_W_gm2_PMOS*1 multi=MOSFET_28_1_M_gm2_PMOS nf=1
     M3 (net58 VB1 VDDA VDDA) pch_ulvt_mac l=MOSFET_0_8_L_BIASCM_PMOS w=MOSFET_0_8_W_BIASCM_PMOS*1 multi=MOSFET_0_8_M_BIASCM_PMOS*4 nf=1
     M2 (net77 VB1 VDDA VDDA) pch_ulvt_mac l=MOSFET_0_8_L_BIASCM_PMOS w=MOSFET_0_8_W_BIASCM_PMOS*1 multi=MOSFET_0_8_M_BIASCM_PMOS*4 nf=1
     M1 (net23 VB1 VDDA VDDA) pch_ulvt_mac l=MOSFET_0_8_L_BIASCM_PMOS w=MOSFET_0_8_W_BIASCM_PMOS*1 multi=MOSFET_0_8_M_BIASCM_PMOS*4 nf=1
     M0 (net9 VB1 VDDA VDDA) pch_ulvt_mac l=MOSFET_0_8_L_BIASCM_PMOS w=MOSFET_0_8_W_BIASCM_PMOS*1 multi=MOSFET_0_8_M_BIASCM_PMOS*4 nf=1
     M57 (VB1 VB2 net9 VDDA) pch_ulvt_mac l=MOSFET_0_8_L_BIASCM_PMOS w=MOSFET_0_8_W_BIASCM_PMOS*1 multi=MOSFET_0_8_M_BIASCM_PMOS*4 nf=1
     M65 (VB2 VB2 VDDA VDDA) pch_ulvt_mac l=MOSFET_0_8_L_BIASCM_PMOS w=MOSFET_0_8_W_BIASCM_PMOS*1 multi=MOSFET_0_8_M_BIASCM_PMOS nf=1
     M21 (net18 VB1 VDDA VDDA) pch_ulvt_mac l=MOSFET_0_8_L_BIASCM_PMOS w=MOSFET_0_8_W_BIASCM_PMOS*1 multi=MOSFET_0_8_M_BIASCM_PMOS*8 nf=1
     M62 (VB3 VB2 net58 VDDA) pch_ulvt_mac l=MOSFET_0_8_L_BIASCM_PMOS w=MOSFET_0_8_W_BIASCM_PMOS*1 multi=MOSFET_0_8_M_BIASCM_PMOS*4 nf=1
     M61 (net78 VB2 net77 VDDA) pch_ulvt_mac l=MOSFET_0_8_L_BIASCM_PMOS w=MOSFET_0_8_W_BIASCM_PMOS*1 multi=MOSFET_0_8_M_BIASCM_PMOS*4 nf=1
     M58 (VB4 VB2 net23 VDDA) pch_ulvt_mac l=MOSFET_0_8_L_BIASCM_PMOS w=MOSFET_0_8_W_BIASCM_PMOS*1 multi=MOSFET_0_8_M_BIASCM_PMOS*4 nf=1
     M41 (net10 VB1 VDDA VDDA) pch_ulvt_mac l=MOSFET_0_8_L_BIASCM_PMOS w=MOSFET_0_8_W_BIASCM_PMOS*1 multi=MOSFET_0_8_M_BIASCM_PMOS*2 nf=1
     M5 (net8 VINP net18 net18) pch_ulvt_mac l=MOSFET_4_1_L_gm1_PMOS w=MOSFET_4_1_W_gm1_PMOS*1 multi=MOSFET_4_1_M_gm1_PMOS nf=1
     M4 (net3 VINN net18 net18) pch_ulvt_mac l=MOSFET_4_1_L_gm1_PMOS w=MOSFET_4_1_W_gm1_PMOS*1 multi=MOSFET_4_1_M_gm1_PMOS nf=1
     M7 (net18 net14 VDDA VDDA) pch_ulvt_mac l=MOSFET_0_8_L_BIASCM_PMOS w=MOSFET_0_8_W_BIASCM_PMOS*1 multi=MOSFET_0_8_M_BIASCM_PMOS*12 nf=1
     M16 (net15 VB2 net18 VDDA) pch_ulvt_mac l=MOSFET_16_1_L_EXTCM_PMOS w=MOSFET_16_1_W_EXTCM_PMOS*1 multi=MOSFET_16_1_M_EXTCM_PMOS nf=1
     M8 (net14 net14 VDDA VDDA) pch_ulvt_mac l=MOSFET_0_8_L_BIASCM_PMOS w=MOSFET_0_8_W_BIASCM_PMOS*1 multi=MOSFET_0_8_M_BIASCM_PMOS*4 nf=1
     C1 (net2 net16) capacitor c=CAPACITOR_0
     C0 (net1 net4) capacitor c=CAPACITOR_0
 ends R2R_SMCNR_PNin_2
 // Library name: TSMC22ULL_Std_AMP_LIB
 // Cell name: TB_TRANR2R_SMCNR_PNin_2
 // View name: schematic
 V0 (VDD 0) vsource dc=VDD type=dc
 C0 (SR_VOUT 0) capacitor c=CLOAD
 I21 (0 VDD SR_VOUT SR_VINP SR_VOUT) R2R_SMCNR_PNin_2
 V1 (SR_VINP 0) vsource dc=0 type=pulse delay=1u edgetype=linear val0=0.1 val1=0.5 period=1 rise=1p fall=1p width=2.00e-07
simulatorOptions options temp=-25
 tran tran stop=1.40e-06
 save SR_VOUT SR_VINP
saveOptions options save=selected

 // Design library name: TSMC22ULL_Std_AMP_LIB
 // Design cell name: TB_Cascode_Miller_Pin_2
 simulator lang=spectre
 global 0
 parameters _EXPR_2=PULSE_WIDTH*10+1u CAPACITOR_0=2.0p MOSFET_68_1_L_gm2_NMOS=0.5u MOSFET_68_1_M_gm2_NMOS=15.0 MOSFET_68_1_W_gm2_NMOS=0.604u CURRENT_0_BIAS=1.0u MOSFET_0_8_L_BIASCM_PMOS=0.18u MOSFET_0_8_M_BIASCM_PMOS=200.0 MOSFET_0_8_W_BIASCM_PMOS=0.782u MOSFET_17_7_L_BIASCM_NMOS=2.62u MOSFET_17_7_M_BIASCM_NMOS=19.0 MOSFET_17_7_W_BIASCM_NMOS=0.22u MOSFET_5_2_L_LOAD1_PMOS=1.0u MOSFET_5_2_M_LOAD1_PMOS=1.0 MOSFET_5_2_W_LOAD1_PMOS=0.22u MOSFET_8_2_L_gm1_PMOS=0.5u MOSFET_8_2_M_gm1_PMOS=157.0 MOSFET_8_2_W_gm1_PMOS=0.534u CLOAD=10p VCM=0.5 VDD=1.62
 include "/home/ic/FAST_240222/src/model/c018bcd_gen2_v1d6_usage.scs" section=ss_lib
include "/home/ic/FAST_240222/src/model/c018bcd_gen2_v1d6_usage.scs" section=pre_simu
// Library name: TSMC22ULL_Std_AMP_LIB
 // Cell name: Cascode_Miller_Pin_2
 // View name: schematic
 subckt Cascode_Miller_Pin_2 GNDA VDDA VINN VINP VOUT
     M6 (net4 VOUTN VDDA VDDA) pch_mac l=MOSFET_5_2_L_LOAD1_PMOS w=MOSFET_5_2_W_LOAD1_PMOS*1 multi=MOSFET_5_2_M_LOAD1_PMOS nf=1
     M5 (VOUTN VOUTN VDDA VDDA) pch_mac l=MOSFET_5_2_L_LOAD1_PMOS w=MOSFET_5_2_W_LOAD1_PMOS*1 multi=MOSFET_5_2_M_LOAD1_PMOS nf=1
     M4 (net3 net102 VDDA VDDA) pch_mac l=MOSFET_0_8_L_BIASCM_PMOS w=MOSFET_0_8_W_BIASCM_PMOS*1 multi=8*MOSFET_0_8_M_BIASCM_PMOS nf=1
     M3 (VB3 net102 VDDA VDDA) pch_mac l=MOSFET_0_8_L_BIASCM_PMOS w=MOSFET_0_8_W_BIASCM_PMOS*1 multi=MOSFET_0_8_M_BIASCM_PMOS*4 nf=1
     M1 (VB4 net102 VDDA VDDA) pch_mac l=MOSFET_0_8_L_BIASCM_PMOS w=MOSFET_0_8_W_BIASCM_PMOS*1 multi=MOSFET_0_8_M_BIASCM_PMOS*4 nf=1
     M0 (net102 net102 VDDA VDDA) pch_mac l=MOSFET_0_8_L_BIASCM_PMOS w=MOSFET_0_8_W_BIASCM_PMOS*1 multi=MOSFET_0_8_M_BIASCM_PMOS*4 nf=1
     M2 (DM_1 DM_1 VDDA VDDA) pch_mac l=MOSFET_0_8_L_BIASCM_PMOS w=MOSFET_0_8_W_BIASCM_PMOS*1 multi=MOSFET_0_8_M_BIASCM_PMOS nf=1
     M9 (net213 VINP net3 net3) pch_mac l=MOSFET_8_2_L_gm1_PMOS w=MOSFET_8_2_W_gm1_PMOS*1 multi=MOSFET_8_2_M_gm1_PMOS nf=1
     M8 (DM_2 VINN net3 net3) pch_mac l=MOSFET_8_2_L_gm1_PMOS w=MOSFET_8_2_W_gm1_PMOS*1 multi=MOSFET_8_2_M_gm1_PMOS nf=1
     M69 (VOUT net102 VDDA VDDA) pch_mac l=MOSFET_0_8_L_BIASCM_PMOS w=MOSFET_0_8_W_BIASCM_PMOS*1 multi=32*MOSFET_0_8_M_BIASCM_PMOS nf=1
     M15 (VOUTN VB3 DM_2 GNDA) nch_mac l=MOSFET_17_7_L_BIASCM_NMOS w=MOSFET_17_7_W_BIASCM_NMOS*1 multi=MOSFET_17_7_M_BIASCM_NMOS*8 nf=1
     M16 (net4 VB3 net213 GNDA) nch_mac l=MOSFET_17_7_L_BIASCM_NMOS w=MOSFET_17_7_W_BIASCM_NMOS*1 multi=MOSFET_17_7_M_BIASCM_NMOS*8 nf=1
     M12 (VB4 VB3 net2 GNDA) nch_mac l=MOSFET_17_7_L_BIASCM_NMOS w=MOSFET_17_7_W_BIASCM_NMOS*1 multi=MOSFET_17_7_M_BIASCM_NMOS*4 nf=1
     M13 (DM_1 VB3 net1 GNDA) nch_mac l=MOSFET_17_7_L_BIASCM_NMOS w=MOSFET_17_7_W_BIASCM_NMOS*1 multi=MOSFET_17_7_M_BIASCM_NMOS*4 nf=1
     M14 (VB3 VB3 GNDA GNDA) nch_mac l=MOSFET_17_7_L_BIASCM_NMOS w=MOSFET_17_7_W_BIASCM_NMOS*1 multi=MOSFET_17_7_M_BIASCM_NMOS nf=1
     M19 (DM_2 VB4 GNDA GNDA) nch_mac l=MOSFET_17_7_L_BIASCM_NMOS w=MOSFET_17_7_W_BIASCM_NMOS*1 multi=MOSFET_17_7_M_BIASCM_NMOS*12 nf=1
     M20 (net213 VB4 GNDA GNDA) nch_mac l=MOSFET_17_7_L_BIASCM_NMOS w=MOSFET_17_7_W_BIASCM_NMOS*1 multi=MOSFET_17_7_M_BIASCM_NMOS*12 nf=1
     M18 (net1 VB4 GNDA GNDA) nch_mac l=MOSFET_17_7_L_BIASCM_NMOS w=MOSFET_17_7_W_BIASCM_NMOS*1 multi=MOSFET_17_7_M_BIASCM_NMOS*4 nf=1
     M17 (net2 VB4 GNDA GNDA) nch_mac l=MOSFET_17_7_L_BIASCM_NMOS w=MOSFET_17_7_W_BIASCM_NMOS*1 multi=MOSFET_17_7_M_BIASCM_NMOS*4 nf=1
     M68 (VOUT net4 GNDA GNDA) nch_mac l=MOSFET_68_1_L_gm2_NMOS w=MOSFET_68_1_W_gm2_NMOS*1 multi=MOSFET_68_1_M_gm2_NMOS nf=1
     I0 (net102 GNDA) isource dc=CURRENT_0_BIAS type=dc
     C0 (net4 VOUT) capacitor c=CAPACITOR_0
 ends Cascode_Miller_Pin_2
 // Library name: TSMC22ULL_Std_AMP_LIB
 // Cell name: TB_Cascode_Miller_Pin_2
 // View name: schematic
 V8 (VDD_PSRR 0) vsource dc=VDD mag=1 type=dc
 V7 (VIN_P_PSRR 0) vsource dc=VCM mag=0 phase=0 type=dc
 V6 (VIN_P_CMRR_TB net17) vsource dc=0 mag=1 phase=0 type=dc
 V5 (VIN_M_CMRR_TB VOUT_CMRR_TB) vsource dc=0 mag=1 phase=0 type=dc
 V3 (net17 0) vsource dc=VCM mag=0 phase=0 type=dc
 V2 (VINP 0) vsource dc=VCM mag=1 phase=0 type=dc
 V0 (VDD 0) vsource dc=VDD type=dc
 C2 (VOUT_PSRR 0) capacitor c=CLOAD
 C1 (VOUT_CMRR_TB 0) capacitor c=CLOAD
 C0 (VOUT 0) capacitor c=CLOAD
 I26 (0 VDD VIN_M VINP VOUT) Cascode_Miller_Pin_2
 I25 (0 VDD_PSRR VIN_M_PSRR VIN_P_PSRR VOUT_PSRR) Cascode_Miller_Pin_2
 I24 (0 VDD VIN_M_CMRR_TB VIN_P_CMRR_TB VOUT_CMRR_TB) Cascode_Miller_Pin_2
 IPRB2 (VOUT_PSRR VIN_M_PSRR) iprobe
 IPRB0 (VOUT VIN_M) iprobe
simulatorOptions options temp=-25
 ac ac start=0.1 stop=10G
 stb stb start=0.01 stop=100G probe=IPRB0 localgnd=0
 dcOp dc
 dc dc param=temp start=-50 stop=150
 noise ( VOUT 0 ) noise start=1 stop=10G iprobe=V2 annotate=status
 pz ( VOUT 0 ) pz iprobe=V2 freq=1 param=VCM start=0 stop=600m
 save VOUT VINP VOUT_CMRR_TB VOUT_PSRR V8:n
saveOptions options save=selected

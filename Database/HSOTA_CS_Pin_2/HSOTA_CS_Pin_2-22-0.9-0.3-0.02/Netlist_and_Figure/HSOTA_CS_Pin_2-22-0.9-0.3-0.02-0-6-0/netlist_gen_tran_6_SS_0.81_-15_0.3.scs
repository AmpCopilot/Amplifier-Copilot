 // Design library name: TSMC22ULL_Std_AMP_LIB
 // Design cell name: TB_TRANHSOTA_CS_Pin_2
 simulator lang=spectre
 global 0
 parameters MOSFET_0_2_L_LOAD0_NMOS=0.4u MOSFET_0_2_M_LOAD0_NMOS=30 MOSFET_0_2_W_LOAD0_NMOS=1.0u MOSFET_13_2_L_gm1_PMOS=0.2u MOSFET_13_2_M_gm1_PMOS=30 MOSFET_13_2_W_gm1_PMOS=1.0u MOSFET_1_2_L_gm2_NMOS=0.2u MOSFET_1_2_M_gm2_NMOS=30 MOSFET_1_2_W_gm2_NMOS=1.0u MOSFET_25_30_L_BIASCM_PMOS=0.3u MOSFET_25_30_M_BIASCM_PMOS=1.0 MOSFET_25_30_W_BIASCM_PMOS=0.1u MOSFET_28_25_L_BIASCM_NMOS=0.4u MOSFET_28_25_M_BIASCM_NMOS=30 MOSFET_28_25_W_BIASCM_NMOS=1.0u MOSFET_6_2_L_LOAD1_PMOS=0.4u MOSFET_6_2_M_LOAD1_PMOS=30 MOSFET_6_2_W_LOAD1_PMOS=1.0u RESISTOR_0=1.2k CURRENT_0_BIAS=25.7u CLOAD=0.02p VCM=0.3 VDD=0.81
 include "/home/soc/zhihc21/7_Amp_complier/OTA_Compiler_v260103_try/Process_Library/22nm_0p9V/models/crn22ull_1d8_elk_v1d3_1p1_shrink0d855_embedded_usage.scs" section=SSMacro_MOS_MOSCAP
include "/home/soc/zhihc21/7_Amp_complier/OTA_Compiler_v260103_try/Process_Library/22nm_0p9V/models/crn22ull_1d8_elk_v1d3_1p1_shrink0d855_embedded_usage.scs" section=pre_simu
// Library name: TSMC22ULL_Std_AMP_LIB
 // Cell name: HSOTA_CS_Pin_2
 // View name: schematic
 subckt HSOTA_CS_Pin_2 GNDA VDDA VINN VINP VOUT
     R1 (net5 net13) resistor r=RESISTOR_0
     R0 (net13 net38) resistor r=RESISTOR_0
     M30 (VBN1 VBN1 GNDA GNDA) nch_ulvt_mac l=MOSFET_28_25_L_BIASCM_NMOS w=MOSFET_28_25_W_BIASCM_NMOS*1 multi=MOSFET_28_25_M_BIASCM_NMOS nf=1
     M31 (VBP2 VBN1 net2 GNDA) nch_ulvt_mac l=MOSFET_28_25_L_BIASCM_NMOS w=MOSFET_28_25_W_BIASCM_NMOS*1 multi=MOSFET_28_25_M_BIASCM_NMOS*4 nf=1
     M28 (VBN2 VBN1 net46 GNDA) nch_ulvt_mac l=MOSFET_28_25_L_BIASCM_NMOS w=MOSFET_28_25_W_BIASCM_NMOS*1 multi=MOSFET_28_25_M_BIASCM_NMOS*4 nf=1
     M29 (net46 VBN2 GNDA GNDA) nch_ulvt_mac l=MOSFET_28_25_L_BIASCM_NMOS w=MOSFET_28_25_W_BIASCM_NMOS*1 multi=MOSFET_28_25_M_BIASCM_NMOS*4 nf=1
     M32 (net2 VBN2 GNDA GNDA) nch_ulvt_mac l=MOSFET_28_25_L_BIASCM_NMOS w=MOSFET_28_25_W_BIASCM_NMOS*1 multi=MOSFET_28_25_M_BIASCM_NMOS*4 nf=1
     M19 (VOUT VBN1 net43 GNDA) nch_ulvt_mac l=MOSFET_28_25_L_BIASCM_NMOS w=MOSFET_28_25_W_BIASCM_NMOS*1 multi=MOSFET_28_25_M_BIASCM_NMOS*8 nf=1
     M15 (net39 VBN1 net41 GNDA) nch_ulvt_mac l=MOSFET_28_25_L_BIASCM_NMOS w=MOSFET_28_25_W_BIASCM_NMOS*1 multi=MOSFET_28_25_M_BIASCM_NMOS*8 nf=1
     I0 (VBP1 GNDA) isource dc=CURRENT_0_BIAS type=dc
     M35 (net1 VBP1 VDDA VDDA) pch_ulvt_mac l=MOSFET_25_30_L_BIASCM_PMOS w=MOSFET_25_30_W_BIASCM_PMOS*1 multi=MOSFET_25_30_M_BIASCM_PMOS*4 nf=1
     M34 (net45 VBP1 VDDA VDDA) pch_ulvt_mac l=MOSFET_25_30_L_BIASCM_PMOS w=MOSFET_25_30_W_BIASCM_PMOS*1 multi=MOSFET_25_30_M_BIASCM_PMOS*4 nf=1
     M33 (net42 VBP1 VDDA VDDA) pch_ulvt_mac l=MOSFET_25_30_L_BIASCM_PMOS w=MOSFET_25_30_W_BIASCM_PMOS*1 multi=MOSFET_25_30_M_BIASCM_PMOS*4 nf=1
     M27 (VBP1 VBP2 net42 VDDA) pch_ulvt_mac l=MOSFET_25_30_L_BIASCM_PMOS w=MOSFET_25_30_W_BIASCM_PMOS*1 multi=MOSFET_25_30_M_BIASCM_PMOS*4 nf=1
     M26 (VBN1 VBP2 net1 VDDA) pch_ulvt_mac l=MOSFET_25_30_L_BIASCM_PMOS w=MOSFET_25_30_W_BIASCM_PMOS*1 multi=MOSFET_25_30_M_BIASCM_PMOS*4 nf=1
     M25 (VBP2 VBP2 VDDA VDDA) pch_ulvt_mac l=MOSFET_25_30_L_BIASCM_PMOS w=MOSFET_25_30_W_BIASCM_PMOS*1 multi=MOSFET_25_30_M_BIASCM_PMOS nf=1
     M24 (VBN2 VBP2 net45 VDDA) pch_ulvt_mac l=MOSFET_25_30_L_BIASCM_PMOS w=MOSFET_25_30_W_BIASCM_PMOS*1 multi=MOSFET_25_30_M_BIASCM_PMOS*4 nf=1
     M21 (VOUT VBP2 net44 VDDA) pch_ulvt_mac l=MOSFET_25_30_L_BIASCM_PMOS w=MOSFET_25_30_W_BIASCM_PMOS*1 multi=MOSFET_25_30_M_BIASCM_PMOS*8 nf=1
     M17 (net39 VBP2 net40 VDDA) pch_ulvt_mac l=MOSFET_25_30_L_BIASCM_PMOS w=MOSFET_25_30_W_BIASCM_PMOS*1 multi=MOSFET_25_30_M_BIASCM_PMOS*8 nf=1
     M12 (net6 VBP1 VDDA VDDA) pch_ulvt_mac l=MOSFET_25_30_L_BIASCM_PMOS w=MOSFET_25_30_W_BIASCM_PMOS*1 multi=MOSFET_25_30_M_BIASCM_PMOS*32 nf=1
     M4 (net44 net39 VDDA VDDA) pch_ulvt_mac l=MOSFET_6_2_L_LOAD1_PMOS w=MOSFET_6_2_W_LOAD1_PMOS*1 multi=MOSFET_6_2_M_LOAD1_PMOS nf=1
     M6 (net40 net39 VDDA VDDA) pch_ulvt_mac l=MOSFET_6_2_L_LOAD1_PMOS w=MOSFET_6_2_W_LOAD1_PMOS*1 multi=MOSFET_6_2_M_LOAD1_PMOS nf=1
     M13 (net5 VINP net6 net6) pch_ulvt_mac l=MOSFET_13_2_L_gm1_PMOS w=MOSFET_13_2_W_gm1_PMOS*1 multi=MOSFET_13_2_M_gm1_PMOS nf=1
     M14 (net38 VINN net6 net6) pch_ulvt_mac l=MOSFET_13_2_L_gm1_PMOS w=MOSFET_13_2_W_gm1_PMOS*1 multi=MOSFET_13_2_M_gm1_PMOS nf=1
     M2 (net41 net38 GNDA GNDA) nch_ulvt_mac l=MOSFET_1_2_L_gm2_NMOS w=MOSFET_1_2_W_gm2_NMOS*1 multi=MOSFET_1_2_M_gm2_NMOS nf=1
     M3 (net5 net13 GNDA GNDA) nch_ulvt_mac l=MOSFET_0_2_L_LOAD0_NMOS w=MOSFET_0_2_W_LOAD0_NMOS*1 multi=MOSFET_0_2_M_LOAD0_NMOS nf=1
     M1 (net43 net5 GNDA GNDA) nch_ulvt_mac l=MOSFET_1_2_L_gm2_NMOS w=MOSFET_1_2_W_gm2_NMOS*1 multi=MOSFET_1_2_M_gm2_NMOS nf=1
     M0 (net38 net13 GNDA GNDA) nch_ulvt_mac l=MOSFET_0_2_L_LOAD0_NMOS w=MOSFET_0_2_W_LOAD0_NMOS*1 multi=MOSFET_0_2_M_LOAD0_NMOS nf=1
 ends HSOTA_CS_Pin_2
 // Library name: TSMC22ULL_Std_AMP_LIB
 // Cell name: TB_TRANHSOTA_CS_Pin_2
 // View name: schematic
 V0 (VDD 0) vsource dc=VDD type=dc
 C0 (SR_VOUT 0) capacitor c=CLOAD
 I17 (0 VDD SR_VOUT SR_VINP SR_VOUT) HSOTA_CS_Pin_2
 V1 (SR_VINP 0) vsource dc=0 type=pulse delay=1u edgetype=linear val0=0.1 val1=0.5 period=1 rise=1p fall=1p width=5.00e-07
simulatorOptions options temp=-15
 tran tran stop=2.00e-06
 save SR_VOUT SR_VINP
saveOptions options save=selected

 // Design library name: TSMC22ULL_Std_AMP_LIB
 // Design cell name: TB_HoiLee_AFFC_Pin_3
 simulator lang=spectre
 global 0
 parameters _EXPR_2=PULSE_WIDTH*10+1u MOSFET_0_8_L_BIASCM_PMOS=0.85u MOSFET_0_8_M_BIASCM_PMOS=514.0 MOSFET_0_8_W_BIASCM_PMOS=0.362u MOSFET_11_1_L_gm2_PMOS=0.735u MOSFET_11_1_M_gm2_PMOS=773.0 MOSFET_11_1_W_gm2_PMOS=0.1u MOSFET_12_1_L_gmf2_PMOS=0.0964u MOSFET_12_1_M_gmf2_PMOS=883.0 MOSFET_12_1_W_gmf2_PMOS=0.859u MOSFET_17_7_L_BIASCM_NMOS=0.847u MOSFET_17_7_M_BIASCM_NMOS=336.0 MOSFET_17_7_W_BIASCM_NMOS=0.248u MOSFET_18_7_L_BIASCM_NMOS=0.707u MOSFET_18_7_M_BIASCM_NMOS=293.0 MOSFET_18_7_W_BIASCM_NMOS=0.134u MOSFET_22_2_L_LOAD2_NMOS=0.263u MOSFET_22_2_M_LOAD2_NMOS=469.0 MOSFET_22_2_W_LOAD2_NMOS=2.05u MOSFET_25_1_L_gm3_NMOS=0.278u MOSFET_25_1_M_gm3_NMOS=955.0 MOSFET_25_1_W_gm3_NMOS=0.49u MOSFET_59_2_L_HSBCM_PMOS=0.638u MOSFET_59_2_M_HSBCM_PMOS=995.0 MOSFET_59_2_W_HSBCM_PMOS=0.1u MOSFET_60_2_L_gma_NMOS=0.295u MOSFET_60_2_M_gma_NMOS=913.0 MOSFET_60_2_W_gma_NMOS=0.852u MOSFET_9_2_L_gm1_PMOS=0.85u MOSFET_9_2_M_gm1_PMOS=1000.0 MOSFET_9_2_W_gm1_PMOS=1.48u CAPACITOR_0=1.56p CAPACITOR_1=1.56p CURRENT_0_BIAS=11.3u CLOAD=120p VCM=0.3 VDD=0.72
 include "/home/soc/zhihc21/7_Amp_complier/FAST_20240508/src/model/spectre_22model/crn22ull_1d8_elk_v1d3_1p1_shrink0d855_embedded_usage.scs" section=ssMacro_MOS_MOSCAP
include "/home/soc/zhihc21/7_Amp_complier/FAST_20240508/src/model/spectre_22model/crn22ull_1d8_elk_v1d3_1p1_shrink0d855_embedded_usage.scs" section=pre_simu
// Library name: TSMC22ULL_Std_AMP_LIB
 // Cell name: HoiLee_AFFC_Pin_3
 // View name: schematic
 subckt HoiLee_AFFC_Pin_3 GNDA VDDA VINN VINP VOUT
     M62 (net050 net2 VDDA VDDA) pch_ulvt_mac l=MOSFET_59_2_L_HSBCM_PMOS w=MOSFET_59_2_W_HSBCM_PMOS*1 multi=MOSFET_59_2_M_HSBCM_PMOS nf=1
     M59 (net2 net2 VDDA VDDA) pch_ulvt_mac l=MOSFET_59_2_L_HSBCM_PMOS w=MOSFET_59_2_W_HSBCM_PMOS*1 multi=MOSFET_59_2_M_HSBCM_PMOS nf=1
     M12 (VOUT net050 VDDA VDDA) pch_ulvt_mac l=MOSFET_12_1_L_gmf2_PMOS w=MOSFET_12_1_W_gmf2_PMOS*1 multi=MOSFET_12_1_M_gmf2_PMOS nf=1
     M7 (net049 net013 VDDA VDDA) pch_ulvt_mac l=MOSFET_0_8_L_BIASCM_PMOS w=MOSFET_0_8_W_BIASCM_PMOS*1 multi=MOSFET_0_8_M_BIASCM_PMOS nf=1
     M11 (net043 net050 VDDA VDDA) pch_ulvt_mac l=MOSFET_11_1_L_gm2_PMOS w=MOSFET_11_1_W_gm2_PMOS*1 multi=MOSFET_11_1_M_gm2_PMOS nf=1
     M6 (net050 VOUTN VDDA VDDA) pch_ulvt_mac l=MOSFET_0_8_L_BIASCM_PMOS w=MOSFET_0_8_W_BIASCM_PMOS*1 multi=MOSFET_0_8_M_BIASCM_PMOS nf=1
     M5 (VOUTN VOUTN VDDA VDDA) pch_ulvt_mac l=MOSFET_0_8_L_BIASCM_PMOS w=MOSFET_0_8_W_BIASCM_PMOS*1 multi=MOSFET_0_8_M_BIASCM_PMOS nf=1
     M10 (net063 VINP net31 net31) pch_ulvt_mac l=MOSFET_9_2_L_gm1_PMOS w=MOSFET_9_2_W_gm1_PMOS*1 multi=MOSFET_9_2_M_gm1_PMOS nf=1
     M9 (DM_2 VINN net31 net31) pch_ulvt_mac l=MOSFET_9_2_L_gm1_PMOS w=MOSFET_9_2_W_gm1_PMOS*1 multi=MOSFET_9_2_M_gm1_PMOS nf=1
     M4 (net31 net013 VDDA VDDA) pch_ulvt_mac l=MOSFET_0_8_L_BIASCM_PMOS w=MOSFET_0_8_W_BIASCM_PMOS*1 multi=2*MOSFET_0_8_M_BIASCM_PMOS nf=1
     M3 (VB3 net013 VDDA VDDA) pch_ulvt_mac l=MOSFET_0_8_L_BIASCM_PMOS w=MOSFET_0_8_W_BIASCM_PMOS*1 multi=MOSFET_0_8_M_BIASCM_PMOS nf=1
     M2 (DM_1 net013 VDDA VDDA) pch_ulvt_mac l=MOSFET_0_8_L_BIASCM_PMOS w=MOSFET_0_8_W_BIASCM_PMOS*1 multi=MOSFET_0_8_M_BIASCM_PMOS nf=1
     M1 (VB4 net013 VDDA VDDA) pch_ulvt_mac l=MOSFET_0_8_L_BIASCM_PMOS w=MOSFET_0_8_W_BIASCM_PMOS*1 multi=MOSFET_0_8_M_BIASCM_PMOS nf=1
     M0 (net013 net013 VDDA VDDA) pch_ulvt_mac l=MOSFET_0_8_L_BIASCM_PMOS w=MOSFET_0_8_W_BIASCM_PMOS*1 multi=MOSFET_0_8_M_BIASCM_PMOS nf=1
     M64 (net1 VB4 GNDA GNDA) nch_ulvt_mac l=MOSFET_18_7_L_BIASCM_NMOS w=MOSFET_18_7_W_BIASCM_NMOS*1 multi=MOSFET_18_7_M_BIASCM_NMOS*4 nf=1
     M63 (net050 VB3 net1 GNDA) nch_ulvt_mac l=MOSFET_60_2_L_gma_NMOS w=MOSFET_60_2_W_gma_NMOS*1 multi=MOSFET_60_2_M_gma_NMOS nf=1
     M61 (net3 VB4 GNDA GNDA) nch_ulvt_mac l=MOSFET_18_7_L_BIASCM_NMOS w=MOSFET_18_7_W_BIASCM_NMOS*1 multi=MOSFET_18_7_M_BIASCM_NMOS*4 nf=1
     M60 (net2 VB3 net3 GNDA) nch_ulvt_mac l=MOSFET_60_2_L_gma_NMOS w=MOSFET_60_2_W_gma_NMOS*1 multi=MOSFET_60_2_M_gma_NMOS nf=1
     M25 (VOUT net049 GNDA GNDA) nch_ulvt_mac l=MOSFET_25_1_L_gm3_NMOS w=MOSFET_25_1_W_gm3_NMOS*1 multi=MOSFET_25_1_M_gm3_NMOS nf=1
     M23 (net049 net043 GNDA GNDA) nch_ulvt_mac l=MOSFET_22_2_L_LOAD2_NMOS w=MOSFET_22_2_W_LOAD2_NMOS*1 multi=MOSFET_22_2_M_LOAD2_NMOS nf=1
     M22 (net043 net043 GNDA GNDA) nch_ulvt_mac l=MOSFET_22_2_L_LOAD2_NMOS w=MOSFET_22_2_W_LOAD2_NMOS*1 multi=MOSFET_22_2_M_LOAD2_NMOS nf=1
     M20 (DM_2 VB4 GNDA GNDA) nch_ulvt_mac l=MOSFET_18_7_L_BIASCM_NMOS w=MOSFET_18_7_W_BIASCM_NMOS*1 multi=MOSFET_18_7_M_BIASCM_NMOS*8 nf=1
     M16 (VOUTN VB3 DM_2 GNDA) nch_ulvt_mac l=MOSFET_17_7_L_BIASCM_NMOS w=MOSFET_17_7_W_BIASCM_NMOS*1 multi=MOSFET_17_7_M_BIASCM_NMOS*4 nf=1
     M21 (net063 VB4 GNDA GNDA) nch_ulvt_mac l=MOSFET_18_7_L_BIASCM_NMOS w=MOSFET_18_7_W_BIASCM_NMOS*1 multi=MOSFET_18_7_M_BIASCM_NMOS*8 nf=1
     M17 (net050 VB3 net063 GNDA) nch_ulvt_mac l=MOSFET_17_7_L_BIASCM_NMOS w=MOSFET_17_7_W_BIASCM_NMOS*1 multi=MOSFET_17_7_M_BIASCM_NMOS*4 nf=1
     M18 (net54 VB4 GNDA GNDA) nch_ulvt_mac l=MOSFET_18_7_L_BIASCM_NMOS w=MOSFET_18_7_W_BIASCM_NMOS*1 multi=MOSFET_18_7_M_BIASCM_NMOS*4 nf=1
     M15 (VB3 VB3 GNDA GNDA) nch_ulvt_mac l=MOSFET_18_7_L_BIASCM_NMOS w=MOSFET_18_7_W_BIASCM_NMOS*1 multi=MOSFET_18_7_M_BIASCM_NMOS nf=1
     M13 (VB4 VB3 net54 GNDA) nch_ulvt_mac l=MOSFET_18_7_L_BIASCM_NMOS w=MOSFET_18_7_W_BIASCM_NMOS*1 multi=MOSFET_18_7_M_BIASCM_NMOS*4 nf=1
     M19 (net56 VB4 GNDA GNDA) nch_ulvt_mac l=MOSFET_18_7_L_BIASCM_NMOS w=MOSFET_18_7_W_BIASCM_NMOS*1 multi=MOSFET_18_7_M_BIASCM_NMOS*4 nf=1
     M14 (DM_1 VB3 net56 GNDA) nch_ulvt_mac l=MOSFET_18_7_L_BIASCM_NMOS w=MOSFET_18_7_W_BIASCM_NMOS*1 multi=MOSFET_18_7_M_BIASCM_NMOS*4 nf=1
     I0 (net013 GNDA) isource dc=CURRENT_0_BIAS type=dc
     C1 (VOUT net1) capacitor c=CAPACITOR_1
     C0 (net049 VOUT) capacitor c=CAPACITOR_0
 ends HoiLee_AFFC_Pin_3
 // Library name: TSMC22ULL_Std_AMP_LIB
 // Cell name: TB_HoiLee_AFFC_Pin_3
 // View name: schematic
 V8 (VDD_PSRR 0) vsource dc=VDD mag=1 type=dc
 V7 (VIN_P_PSRR 0) vsource dc=VCM mag=0 phase=0 type=dc
 V6 (VIN_P_CMRR_TB net17) vsource dc=0 mag=1 phase=0 type=dc
 V5 (VIN_M_CMRR_TB VOUT_CMRR_TB) vsource dc=0 mag=1 phase=0 type=dc
 V3 (net17 0) vsource dc=VCM mag=0 phase=0 type=dc
 V2 (VINP 0) vsource dc=VCM mag=1 phase=0 type=dc
 V0 (VDD 0) vsource dc=VDD type=dc
 C2 (VOUT_PSRR 0) capacitor c=CLOAD
 C1 (VOUT_CMRR_TB 0) capacitor c=CLOAD
 C0 (VOUT 0) capacitor c=CLOAD
 I35 (0 VDD VIN_M VINP VOUT) HoiLee_AFFC_Pin_3
 I34 (0 VDD_PSRR VIN_M_PSRR VIN_P_PSRR VOUT_PSRR) HoiLee_AFFC_Pin_3
 I33 (0 VDD VIN_M_CMRR_TB VIN_P_CMRR_TB VOUT_CMRR_TB) HoiLee_AFFC_Pin_3
 IPRB2 (VOUT_PSRR VIN_M_PSRR) iprobe
 IPRB0 (VOUT VIN_M) iprobe
simulatorOptions options temp=-25
 ac ac start=0.1 stop=10G
 stb stb start=0.01 stop=100G probe=IPRB0 localgnd=0
 dcOp dc
 dc dc param=temp start=-50 stop=150
 noise ( VOUT 0 ) noise start=1 stop=10G iprobe=V2 annotate=status
 pz ( VOUT 0 ) pz iprobe=V2 freq=1 param=VCM start=0 stop=600m
 save VOUT VINP VOUT_CMRR_TB VOUT_PSRR V8:n
saveOptions options save=selected

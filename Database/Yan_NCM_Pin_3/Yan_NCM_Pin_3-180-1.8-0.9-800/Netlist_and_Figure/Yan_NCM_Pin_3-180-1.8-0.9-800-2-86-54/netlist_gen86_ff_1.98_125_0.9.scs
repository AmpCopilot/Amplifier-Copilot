 // Design library name: TSMC22ULL_Std_AMP_LIB
 // Design cell name: TB_Yan_NCM_Pin_1
 simulator lang=spectre
 global 0
 parameters _EXPR_2=PULSE_WIDTH*10+1u MOSFET_0_8_L_BIASCM_PMOS=20.0u MOSFET_0_8_M_BIASCM_PMOSM=9.0 MOSFET_0_8_W_BIASCM_PMOS=0.22u MOSFET_13_2_L_CM31_PMOS=20.0u MOSFET_13_2_M_CM31_PMOS=1.0 MOSFET_13_2_W_CM31_PMOS=0.22u MOSFET_14_2_L_CM21_PMOS=0.18u MOSFET_14_2_M_CM21_PMOS=4.0 MOSFET_14_2_W_CM21_PMOS=2.67u MOSFET_15_2_L_CM11_PMOS=0.18u MOSFET_15_2_M_CM11_PMOS=193.0 MOSFET_15_2_W_CM11_PMOS=8.68u MOSFET_16_2_L_CM22_PMOS=0.18u MOSFET_16_2_M_CM22_PMOS=1.0 MOSFET_16_2_W_CM22_PMOS=10.0u MOSFET_17_2_L_CM32_PMOS=0.793u MOSFET_17_2_M_CM32_PMOS=1.0 MOSFET_17_2_W_CM32_PMOS=9.98u MOSFET_18_2_L_CM12_PMOS=11.6u MOSFET_18_2_M_CM12_PMOS=200.0 MOSFET_18_2_W_CM12_PMOS=0.286u MOSFET_1_2_L_gm1_PMOS=15.6u MOSFET_1_2_M_gm1_PMOS=200.0 MOSFET_1_2_W_gm1_PMOS=0.985u MOSFET_3_4_L_gm12_PMOS=0.743u MOSFET_3_4_M_gm12_PMOS=200.0 MOSFET_3_4_W_gm12_PMOS=0.22u MOSFET_7_2_L_CM_PMOS=2.93u MOSFET_7_2_M_CM_PMOS=130.0 MOSFET_7_2_W_CM_PMOS=0.277u CURRENT_0_BIAS=0.436u CLOAD=500p VCM=0.9 VDD=1.98
 include "/home/soc/zhihc21/7_Amp_complier/FAST_20240508/src/model/c018bcd_gen2_v1d6_usage.scs" section=ff_lib
include "/home/soc/zhihc21/7_Amp_complier/FAST_20240508/src/model/c018bcd_gen2_v1d6_usage.scs" section=pre_simu
// Library name: TSMC22ULL_Std_AMP_LIB
 // Cell name: Yan_NCM_Pin_1
 // View name: schematic
 subckt Yan_NCM_Pin_1 GNDA VDDA VINN VINP VOUT
     M21 (Vb Vb VDDA VDDA) pch_mac l=MOSFET_0_8_L_BIASCM_PMOS w=MOSFET_0_8_W_BIASCM_PMOS*1 multi=MOSFET_0_8_M_BIASCM_PMOSM nf=1
     M8 (VOUT net1 VDDA VDDA) pch_mac l=MOSFET_7_2_L_CM_PMOS w=MOSFET_7_2_W_CM_PMOS*1 multi=MOSFET_7_2_M_CM_PMOS nf=1
     M7 (net1 net1 VDDA VDDA) pch_mac l=MOSFET_7_2_L_CM_PMOS w=MOSFET_7_2_W_CM_PMOS*1 multi=MOSFET_7_2_M_CM_PMOS nf=1
     M6 (net5 VINP net2 net2) pch_mac l=MOSFET_3_4_L_gm12_PMOS w=MOSFET_3_4_W_gm12_PMOS*1 multi=MOSFET_3_4_M_gm12_PMOS nf=1
     M5 (net4 VINN net2 net2) pch_mac l=MOSFET_3_4_L_gm12_PMOS w=MOSFET_3_4_W_gm12_PMOS*1 multi=MOSFET_3_4_M_gm12_PMOS nf=1
     M4 (net3 VINP net2 net2) pch_mac l=MOSFET_1_2_L_gm1_PMOS w=MOSFET_1_2_W_gm1_PMOS*1 multi=MOSFET_1_2_M_gm1_PMOS nf=1
     M3 (net6 VINN net2 net2) pch_mac l=MOSFET_3_4_L_gm12_PMOS w=MOSFET_3_4_W_gm12_PMOS*1 multi=MOSFET_3_4_M_gm12_PMOS nf=1
     M2 (net7 VINP net2 net2) pch_mac l=MOSFET_3_4_L_gm12_PMOS w=MOSFET_3_4_W_gm12_PMOS*1 multi=MOSFET_3_4_M_gm12_PMOS nf=1
     M1 (net8 VINN net2 net2) pch_mac l=MOSFET_1_2_L_gm1_PMOS w=MOSFET_1_2_W_gm1_PMOS*1 multi=MOSFET_1_2_M_gm1_PMOS nf=1
     M0 (net2 Vb VDDA VDDA) pch_mac l=MOSFET_0_8_L_BIASCM_PMOS w=MOSFET_0_8_W_BIASCM_PMOS*1 multi=MOSFET_0_8_M_BIASCM_PMOSM nf=1
     M20 (net5 net5 GNDA GNDA) nch_mac l=MOSFET_13_2_L_CM31_PMOS w=MOSFET_13_2_W_CM31_PMOS*1 multi=MOSFET_13_2_M_CM31_PMOS nf=1
     M19 (net4 net4 GNDA GNDA) nch_mac l=MOSFET_14_2_L_CM21_PMOS w=MOSFET_14_2_W_CM21_PMOS*1 multi=MOSFET_14_2_M_CM21_PMOS nf=1
     M18 (net7 net8 GNDA GNDA) nch_mac l=MOSFET_18_2_L_CM12_PMOS w=MOSFET_18_2_W_CM12_PMOS*1 multi=MOSFET_18_2_M_CM12_PMOS nf=1
     M17 (net1 net6 GNDA GNDA) nch_mac l=MOSFET_17_2_L_CM32_PMOS w=MOSFET_17_2_W_CM32_PMOS*1 multi=MOSFET_17_2_M_CM32_PMOS nf=1
     M16 (net6 net7 GNDA GNDA) nch_mac l=MOSFET_16_2_L_CM22_PMOS w=MOSFET_16_2_W_CM22_PMOS*1 multi=MOSFET_16_2_M_CM22_PMOS nf=1
     M15 (net8 net8 GNDA GNDA) nch_mac l=MOSFET_15_2_L_CM11_PMOS w=MOSFET_15_2_W_CM11_PMOS*1 multi=MOSFET_15_2_M_CM11_PMOS nf=1
     M14 (net7 net7 GNDA GNDA) nch_mac l=MOSFET_14_2_L_CM21_PMOS w=MOSFET_14_2_W_CM21_PMOS*1 multi=MOSFET_14_2_M_CM21_PMOS nf=1
     M13 (net6 net6 GNDA GNDA) nch_mac l=MOSFET_13_2_L_CM31_PMOS w=MOSFET_13_2_W_CM31_PMOS*1 multi=MOSFET_13_2_M_CM31_PMOS nf=1
     M12 (net3 net3 GNDA GNDA) nch_mac l=MOSFET_15_2_L_CM11_PMOS w=MOSFET_15_2_W_CM11_PMOS*1 multi=MOSFET_15_2_M_CM11_PMOS nf=1
     M11 (net4 net3 GNDA GNDA) nch_mac l=MOSFET_18_2_L_CM12_PMOS w=MOSFET_18_2_W_CM12_PMOS*1 multi=MOSFET_18_2_M_CM12_PMOS nf=1
     M10 (net5 net4 GNDA GNDA) nch_mac l=MOSFET_16_2_L_CM22_PMOS w=MOSFET_16_2_W_CM22_PMOS*1 multi=MOSFET_16_2_M_CM22_PMOS nf=1
     M9 (VOUT net5 GNDA GNDA) nch_mac l=MOSFET_17_2_L_CM32_PMOS w=MOSFET_17_2_W_CM32_PMOS*1 multi=MOSFET_17_2_M_CM32_PMOS nf=1
     I0 (Vb GNDA) isource dc=CURRENT_0_BIAS type=dc
 ends Yan_NCM_Pin_1
 // Library name: TSMC22ULL_Std_AMP_LIB
 // Cell name: TB_Yan_NCM_Pin_1
 // View name: schematic
 V8 (VDD_PSRR 0) vsource dc=VDD mag=1 type=dc
 V7 (VIN_P_PSRR 0) vsource dc=VCM mag=0 phase=0 type=dc
 V6 (VIN_P_CMRR_TB net17) vsource dc=0 mag=1 phase=0 type=dc
 V5 (VIN_M_CMRR_TB VOUT_CMRR_TB) vsource dc=0 mag=1 phase=0 type=dc
 V3 (net17 0) vsource dc=VCM mag=0 phase=0 type=dc
 V2 (VINP 0) vsource dc=VCM mag=1 phase=0 type=dc
 V0 (VDD 0) vsource dc=VDD type=dc
 C2 (VOUT_PSRR 0) capacitor c=CLOAD
 C1 (VOUT_CMRR_TB 0) capacitor c=CLOAD
 C0 (VOUT 0) capacitor c=CLOAD
 I32 (0 VDD VIN_M VINP VOUT) Yan_NCM_Pin_1
 I31 (0 VDD_PSRR VIN_M_PSRR VIN_P_PSRR VOUT_PSRR) Yan_NCM_Pin_1
 I30 (0 VDD VIN_M_CMRR_TB VIN_P_CMRR_TB VOUT_CMRR_TB) Yan_NCM_Pin_1
 IPRB2 (VOUT_PSRR VIN_M_PSRR) iprobe
 IPRB0 (VOUT VIN_M) iprobe
simulatorOptions options temp=125
 ac ac start=0.1 stop=10G
 stb stb start=0.01 stop=100G probe=IPRB0 localgnd=0
 dcOp dc
 dc dc param=temp start=-50 stop=150
 noise ( VOUT 0 ) noise start=1 stop=10G iprobe=V2 annotate=status
 pz ( VOUT 0 ) pz iprobe=V2 freq=1 param=VCM start=0 stop=600m
 save VOUT VINP VOUT_CMRR_TB VOUT_PSRR V8:n
saveOptions options save=selected

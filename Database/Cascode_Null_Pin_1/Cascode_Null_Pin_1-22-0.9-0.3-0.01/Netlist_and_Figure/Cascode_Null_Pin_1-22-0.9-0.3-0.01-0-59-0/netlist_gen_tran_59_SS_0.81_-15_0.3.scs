 // Design library name: TSMC22ULL_Std_AMP_LIB
 // Design cell name: TB_TRANCascode_Null_Pin_1
 simulator lang=spectre
 global 0
 parameters CURRENT_0_BIAS=19.0u MOSFET_0_8_L_BIASCM_PMOS=0.2u MOSFET_0_8_M_BIASCM_PMOS=6.0 MOSFET_0_8_W_BIASCM_PMOS=0.7u MOSFET_17_7_L_BIASCM_NMOS=0.3u MOSFET_17_7_M_BIASCM_NMOS=1.0 MOSFET_17_7_W_BIASCM_NMOS=1.0u MOSFET_5_2_L_LOAD1_PMOS=0.2u MOSFET_5_2_M_LOAD1_PMOS=1.0 MOSFET_5_2_W_LOAD1_PMOS=0.8u MOSFET_8_2_L_gm1_PMOS=0.2u MOSFET_8_2_M_gm1_PMOS=6.0 MOSFET_8_2_W_gm1_PMOS=1.0u CLOAD=0.01p VCM=0.3 VDD=0.81
 include "/home/soc/zhihc21/7_Amp_complier/OTA_Compiler_v260103_try/Process_Library/22nm_0p9V/models/crn22ull_1d8_elk_v1d3_1p1_shrink0d855_embedded_usage.scs" section=SSMacro_MOS_MOSCAP
include "/home/soc/zhihc21/7_Amp_complier/OTA_Compiler_v260103_try/Process_Library/22nm_0p9V/models/crn22ull_1d8_elk_v1d3_1p1_shrink0d855_embedded_usage.scs" section=pre_simu
// Library name: TSMC22ULL_Std_AMP_LIB
 // Cell name: Cascode_Null_Pin_1
 // View name: schematic
 subckt Cascode_Null_Pin_1 GNDA VDDA VINN VINP VOUT
     M15 (VOUTN VB3 DM_2 GNDA) nch_ulvt_mac l=MOSFET_17_7_L_BIASCM_NMOS w=MOSFET_17_7_W_BIASCM_NMOS*1 multi=MOSFET_17_7_M_BIASCM_NMOS*4 nf=1
     M16 (VOUT VB3 net213 GNDA) nch_ulvt_mac l=MOSFET_17_7_L_BIASCM_NMOS w=MOSFET_17_7_W_BIASCM_NMOS*1 multi=MOSFET_17_7_M_BIASCM_NMOS*4 nf=1
     M12 (VB4 VB3 net1 GNDA) nch_ulvt_mac l=MOSFET_17_7_L_BIASCM_NMOS w=MOSFET_17_7_W_BIASCM_NMOS*1 multi=MOSFET_17_7_M_BIASCM_NMOS*4 nf=1
     M14 (VB3 VB3 GNDA GNDA) nch_ulvt_mac l=MOSFET_17_7_L_BIASCM_NMOS w=MOSFET_17_7_W_BIASCM_NMOS*1 multi=MOSFET_17_7_M_BIASCM_NMOS nf=1
     M19 (DM_2 VB4 GNDA GNDA) nch_ulvt_mac l=MOSFET_17_7_L_BIASCM_NMOS w=MOSFET_17_7_W_BIASCM_NMOS*1 multi=MOSFET_17_7_M_BIASCM_NMOS*8 nf=1
     M20 (net213 VB4 GNDA GNDA) nch_ulvt_mac l=MOSFET_17_7_L_BIASCM_NMOS w=MOSFET_17_7_W_BIASCM_NMOS*1 multi=MOSFET_17_7_M_BIASCM_NMOS*8 nf=1
     M17 (net1 VB4 GNDA GNDA) nch_ulvt_mac l=MOSFET_17_7_L_BIASCM_NMOS w=MOSFET_17_7_W_BIASCM_NMOS*1 multi=MOSFET_17_7_M_BIASCM_NMOS*4 nf=1
     M6 (VOUT VOUTN VDDA VDDA) pch_ulvt_mac l=MOSFET_5_2_L_LOAD1_PMOS w=MOSFET_5_2_W_LOAD1_PMOS*1 multi=MOSFET_5_2_M_LOAD1_PMOS nf=1
     M5 (VOUTN VOUTN VDDA VDDA) pch_ulvt_mac l=MOSFET_5_2_L_LOAD1_PMOS w=MOSFET_5_2_W_LOAD1_PMOS*1 multi=MOSFET_5_2_M_LOAD1_PMOS nf=1
     M4 (net3 net159 VDDA VDDA) pch_ulvt_mac l=MOSFET_0_8_L_BIASCM_PMOS w=MOSFET_0_8_W_BIASCM_PMOS*1 multi=2*MOSFET_0_8_M_BIASCM_PMOS nf=1
     M3 (VB3 net159 VDDA VDDA) pch_ulvt_mac l=MOSFET_0_8_L_BIASCM_PMOS w=MOSFET_0_8_W_BIASCM_PMOS*1 multi=MOSFET_0_8_M_BIASCM_PMOS nf=1
     M1 (VB4 net159 VDDA VDDA) pch_ulvt_mac l=MOSFET_0_8_L_BIASCM_PMOS w=MOSFET_0_8_W_BIASCM_PMOS*1 multi=MOSFET_0_8_M_BIASCM_PMOS nf=1
     M0 (net159 net159 VDDA VDDA) pch_ulvt_mac l=MOSFET_0_8_L_BIASCM_PMOS w=MOSFET_0_8_W_BIASCM_PMOS*1 multi=MOSFET_0_8_M_BIASCM_PMOS nf=1
     M9 (net213 VINN net3 net3) pch_ulvt_mac l=MOSFET_8_2_L_gm1_PMOS w=MOSFET_8_2_W_gm1_PMOS*1 multi=MOSFET_8_2_M_gm1_PMOS nf=1
     M8 (DM_2 VINP net3 net3) pch_ulvt_mac l=MOSFET_8_2_L_gm1_PMOS w=MOSFET_8_2_W_gm1_PMOS*1 multi=MOSFET_8_2_M_gm1_PMOS nf=1
     I0 (net159 GNDA) isource dc=CURRENT_0_BIAS type=dc
 ends Cascode_Null_Pin_1
 // Library name: TSMC22ULL_Std_AMP_LIB
 // Cell name: TB_TRANCascode_Null_Pin_1
 // View name: schematic
 V0 (VDD 0) vsource dc=VDD type=dc
 C0 (SR_VOUT 0) capacitor c=CLOAD
 I17 (0 VDD SR_VOUT SR_VINP SR_VOUT) Cascode_Null_Pin_1
 V1 (SR_VINP 0) vsource dc=0 type=pulse delay=1u edgetype=linear val0=0.1 val1=0.5 period=1 rise=1p fall=1p width=5.00e-07
simulatorOptions options temp=-15
 tran tran stop=2.00e-06
 save SR_VOUT SR_VINP
saveOptions options save=selected

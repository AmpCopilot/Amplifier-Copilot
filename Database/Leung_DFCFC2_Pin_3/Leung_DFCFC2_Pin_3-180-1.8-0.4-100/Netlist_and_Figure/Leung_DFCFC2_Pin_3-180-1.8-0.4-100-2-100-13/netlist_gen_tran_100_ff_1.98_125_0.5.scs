 // Design library name: TSMC22ULL_Std_AMP_LIB
 // Design cell name: TB_TRANLeung_DFCFC2_Pin_3
 simulator lang=spectre
 global 0
 parameters MOSFET_0_8_L_BIASCM_PMOS=0.5u MOSFET_0_8_M_BIASCM_PMOS=22.0 MOSFET_0_8_W_BIASCM_PMOS=0.963u MOSFET_10_1_L_gm4_PMOS=0.5u MOSFET_10_1_M_gm4_PMOS=13.0 MOSFET_10_1_W_gm4_PMOS=0.919u MOSFET_11_1_L_gm2_PMOS=0.5u MOSFET_11_1_M_gm2_PMOS=11.0 MOSFET_11_1_W_gm2_PMOS=0.999u MOSFET_12_1_L_gmf2_PMOS=0.5u MOSFET_12_1_M_gmf2_PMOS=13.0 MOSFET_12_1_W_gmf2_PMOS=0.968u MOSFET_18_7_L_BIASCM_NMOS=0.5u MOSFET_18_7_M_BIASCM_NMOS=1.0 MOSFET_18_7_W_BIASCM_NMOS=0.974u MOSFET_23_2_L_LOAD2_NMOS=1.0u MOSFET_23_2_M_LOAD2_NMOS=8.0 MOSFET_23_2_W_LOAD2_NMOS=0.953u MOSFET_25_1_L_gm3_NMOS=0.5u MOSFET_25_1_M_gm3_NMOS=18.0 MOSFET_25_1_W_gm3_NMOS=0.935u MOSFET_8_2_L_gm1_PMOS=0.5u MOSFET_8_2_M_gm1_PMOS=22.0 MOSFET_8_2_W_gm1_PMOS=0.941u CAPACITOR_0=3.85p CAPACITOR_1=0.5p CURRENT_0_BIAS=5.0u CLOAD=100p VCM=0.5 VDD=1.98
 include "/home/ic/FAST_240222/src/model/c018bcd_gen2_v1d6_usage.scs" section=ff_lib
include "/home/ic/FAST_240222/src/model/c018bcd_gen2_v1d6_usage.scs" section=pre_simu
// Library name: TSMC22ULL_Std_AMP_LIB
 // Cell name: Leung_DFCFC2_Pin_3
 // View name: schematic
 subckt Leung_DFCFC2_Pin_3 GNDA VDDA VINN VINP VOUT
     M12 (VOUT net050 VDDA VDDA) pch_mac l=MOSFET_12_1_L_gmf2_PMOS w=MOSFET_12_1_W_gmf2_PMOS*1 multi=MOSFET_12_1_M_gmf2_PMOS nf=1
     M7 (net049 net1 VDDA VDDA) pch_mac l=MOSFET_0_8_L_BIASCM_PMOS w=MOSFET_0_8_W_BIASCM_PMOS*1 multi=MOSFET_0_8_M_BIASCM_PMOS nf=1
     M11 (net043 net050 VDDA VDDA) pch_mac l=MOSFET_11_1_L_gm2_PMOS w=MOSFET_11_1_W_gm2_PMOS*1 multi=MOSFET_11_1_M_gm2_PMOS nf=1
     M10 (net2 net050 VDDA VDDA) pch_mac l=MOSFET_10_1_L_gm4_PMOS w=MOSFET_10_1_W_gm4_PMOS*1 multi=MOSFET_10_1_M_gm4_PMOS nf=1
     M6 (net050 VOUTN VDDA VDDA) pch_mac l=MOSFET_0_8_L_BIASCM_PMOS w=MOSFET_0_8_W_BIASCM_PMOS*1 multi=MOSFET_0_8_M_BIASCM_PMOS nf=1
     M5 (VOUTN VOUTN VDDA VDDA) pch_mac l=MOSFET_0_8_L_BIASCM_PMOS w=MOSFET_0_8_W_BIASCM_PMOS*1 multi=MOSFET_0_8_M_BIASCM_PMOS nf=1
     M9 (net063 VINP net31 net31) pch_mac l=MOSFET_8_2_L_gm1_PMOS w=MOSFET_8_2_W_gm1_PMOS*1 multi=MOSFET_8_2_M_gm1_PMOS nf=1
     M8 (DM_2 VINN net31 net31) pch_mac l=MOSFET_8_2_L_gm1_PMOS w=MOSFET_8_2_W_gm1_PMOS*1 multi=MOSFET_8_2_M_gm1_PMOS nf=1
     M4 (net31 net1 VDDA VDDA) pch_mac l=MOSFET_0_8_L_BIASCM_PMOS w=MOSFET_0_8_W_BIASCM_PMOS*1 multi=2*MOSFET_0_8_M_BIASCM_PMOS nf=1
     M3 (VB3 net1 VDDA VDDA) pch_mac l=MOSFET_0_8_L_BIASCM_PMOS w=MOSFET_0_8_W_BIASCM_PMOS*1 multi=MOSFET_0_8_M_BIASCM_PMOS nf=1
     M2 (DM_1 net1 VDDA VDDA) pch_mac l=MOSFET_0_8_L_BIASCM_PMOS w=MOSFET_0_8_W_BIASCM_PMOS*1 multi=MOSFET_0_8_M_BIASCM_PMOS nf=1
     M1 (VB4 net1 VDDA VDDA) pch_mac l=MOSFET_0_8_L_BIASCM_PMOS w=MOSFET_0_8_W_BIASCM_PMOS*1 multi=MOSFET_0_8_M_BIASCM_PMOS nf=1
     M0 (net1 net1 VDDA VDDA) pch_mac l=MOSFET_0_8_L_BIASCM_PMOS w=MOSFET_0_8_W_BIASCM_PMOS*1 multi=MOSFET_0_8_M_BIASCM_PMOS nf=1
     M25 (VOUT net049 GNDA GNDA) nch_mac l=MOSFET_25_1_L_gm3_NMOS w=MOSFET_25_1_W_gm3_NMOS*1 multi=MOSFET_25_1_M_gm3_NMOS nf=1
     M24 (net049 net043 GNDA GNDA) nch_mac l=MOSFET_23_2_L_LOAD2_NMOS w=MOSFET_23_2_W_LOAD2_NMOS*1 multi=MOSFET_23_2_M_LOAD2_NMOS nf=1
     M23 (net043 net043 GNDA GNDA) nch_mac l=MOSFET_23_2_L_LOAD2_NMOS w=MOSFET_23_2_W_LOAD2_NMOS*1 multi=MOSFET_23_2_M_LOAD2_NMOS nf=1
     M20 (DM_2 VB4 GNDA GNDA) nch_mac l=MOSFET_18_7_L_BIASCM_NMOS w=MOSFET_18_7_W_BIASCM_NMOS*1 multi=MOSFET_18_7_M_BIASCM_NMOS*8 nf=1
     M16 (VOUTN VB3 DM_2 GNDA) nch_mac l=MOSFET_18_7_L_BIASCM_NMOS w=MOSFET_18_7_W_BIASCM_NMOS*1 multi=MOSFET_18_7_M_BIASCM_NMOS*4 nf=1
     M21 (net063 VB4 GNDA GNDA) nch_mac l=MOSFET_18_7_L_BIASCM_NMOS w=MOSFET_18_7_W_BIASCM_NMOS*1 multi=MOSFET_18_7_M_BIASCM_NMOS*8 nf=1
     M17 (net050 VB3 net063 GNDA) nch_mac l=MOSFET_18_7_L_BIASCM_NMOS w=MOSFET_18_7_W_BIASCM_NMOS*1 multi=MOSFET_18_7_M_BIASCM_NMOS*4 nf=1
     M18 (net54 VB4 GNDA GNDA) nch_mac l=MOSFET_18_7_L_BIASCM_NMOS w=MOSFET_18_7_W_BIASCM_NMOS*1 multi=MOSFET_18_7_M_BIASCM_NMOS*4 nf=1
     M22 (net2 VB4 GNDA GNDA) nch_mac l=MOSFET_18_7_L_BIASCM_NMOS w=MOSFET_18_7_W_BIASCM_NMOS*1 multi=MOSFET_18_7_M_BIASCM_NMOS*4 nf=1
     M15 (VB3 VB3 GNDA GNDA) nch_mac l=MOSFET_18_7_L_BIASCM_NMOS w=MOSFET_18_7_W_BIASCM_NMOS*1 multi=MOSFET_18_7_M_BIASCM_NMOS nf=1
     M13 (VB4 VB3 net54 GNDA) nch_mac l=MOSFET_18_7_L_BIASCM_NMOS w=MOSFET_18_7_W_BIASCM_NMOS*1 multi=MOSFET_18_7_M_BIASCM_NMOS*4 nf=1
     M19 (net56 VB4 GNDA GNDA) nch_mac l=MOSFET_18_7_L_BIASCM_NMOS w=MOSFET_18_7_W_BIASCM_NMOS*1 multi=MOSFET_18_7_M_BIASCM_NMOS*4 nf=1
     M14 (DM_1 VB3 net56 GNDA) nch_mac l=MOSFET_18_7_L_BIASCM_NMOS w=MOSFET_18_7_W_BIASCM_NMOS*1 multi=MOSFET_18_7_M_BIASCM_NMOS*4 nf=1
     I0 (net1 GNDA) isource dc=CURRENT_0_BIAS type=dc
     C1 (net050 VOUT) capacitor c=CAPACITOR_0
     C2 (net050 net2) capacitor c=CAPACITOR_1
 ends Leung_DFCFC2_Pin_3
 // Library name: TSMC22ULL_Std_AMP_LIB
 // Cell name: TB_TRANLeung_DFCFC2_Pin_3
 // View name: schematic
 V0 (VDD 0) vsource dc=VDD type=dc
 C0 (SR_VOUT 0) capacitor c=CLOAD
 I17 (0 VDD SR_VOUT SR_VINP SR_VOUT) Leung_DFCFC2_Pin_3
 V1 (SR_VINP 0) vsource dc=0 type=pulse delay=1u edgetype=linear val0=0.3 val1=0.5 period=1 rise=1p fall=1p width=4.40e-06
simulatorOptions options temp=125
 tran tran stop=9.80e-06
 save SR_VOUT SR_VINP
saveOptions options save=selected

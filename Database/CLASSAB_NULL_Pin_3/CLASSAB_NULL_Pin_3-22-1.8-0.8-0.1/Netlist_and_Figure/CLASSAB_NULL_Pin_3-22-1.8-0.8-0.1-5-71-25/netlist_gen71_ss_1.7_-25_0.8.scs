 // Design library name: 2025_5_DCDC_TO
 // Design cell name: TB_CLASSAB_NULL_Pin_3
 simulator lang=spectre
 global 0
 parameters _EXPR_2=PULSE_WIDTH*10+1u MOSFET_0_1_L_BIASCM_NMOS=0.999u MOSFET_0_1_M_BIASCM_NMOS=6.0 MOSFET_0_1_W_BIASCM_NMOS=0.875u MOSFET_10_1_L_gm1_PMOS=0.277u MOSFET_10_1_M_gm1_PMOS=4.0 MOSFET_10_1_W_gm1_PMOS=1.92u MOSFET_12_1_L_gm2_NMOS=0.772u MOSFET_12_1_M_gm2_NMOS=1.0 MOSFET_12_1_W_gm2_NMOS=0.931u MOSFET_13_1_L_BIASCM_NMOS=0.713u MOSFET_13_1_M_BIASCM_NMOS=6.0 MOSFET_13_1_W_BIASCM_NMOS=1.97u MOSFET_14_1_L_BIASCM_PMOS=0.966u MOSFET_14_1_M_BIASCM_PMOS=46.0 MOSFET_14_1_W_BIASCM_PMOS=0.659u MOSFET_15_1_L_BIASCM_PMOS=0.51u MOSFET_15_1_M_BIASCM_PMOS=28.0 MOSFET_15_1_W_BIASCM_PMOS=1.46u MOSFET_18_1_L_BIASCM_PMOS=0.555u MOSFET_18_1_M_BIASCM_PMOS=2.0 MOSFET_18_1_W_BIASCM_PMOS=0.3u MOSFET_21_1_L_BIASCM_NMOS=0.272u MOSFET_21_1_M_BIASCM_NMOS=1.0 MOSFET_21_1_W_BIASCM_NMOS=0.506u MOSFET_22_1_L_BIASCM_PMOS=0.399u MOSFET_22_1_M_BIASCM_PMOS=25.0 MOSFET_22_1_W_BIASCM_PMOS=1.47u MOSFET_28_1_L_gm3_PMOS=0.303u MOSFET_28_1_M_gm3_PMOS=45.0 MOSFET_28_1_W_gm3_PMOS=1.52u MOSFET_29_1_L_gm3_NMOS=0.696u MOSFET_29_1_M_gm3_NMOS=42.0 MOSFET_29_1_W_gm3_NMOS=1.18u MOSFET_4_1_L_LOAD_NMOS=0.504u MOSFET_4_1_M_LOAD_NMOS=28.0 MOSFET_4_1_W_LOAD_NMOS=0.918u MOSFET_6_1_L_BIASCM_PMOS=0.766u MOSFET_6_1_M_BIASCM_NMOS=10.0 MOSFET_6_1_M_BIASCM_PMOS=10.0 RESISTOR_0=40.0k RESISTOR_1=39.0k MOSFET_6_1_W_BIASCM_PMOS=1.18u CURRENT_0_BIAS=1.8u CLOAD=0.1p VCM=0.8 VDD=1.7
 include "/home/soc/zhihc21/7_Amp_complier/FAST_20240508/src/model/spectre_22model/crn22ull_1d8_elk_v1d3_1p1_shrink0d855_embedded_usage.scs" section=ssMacro_MOS_MOSCAP
include "/home/soc/zhihc21/7_Amp_complier/FAST_20240508/src/model/spectre_22model/crn22ull_1d8_elk_v1d3_1p1_shrink0d855_embedded_usage.scs" section=pre_simu
// Library name: 2025_5_DCDC_TO
 // Cell name: CLASSAB_NULL_Pin_3
 // View name: schematic
 subckt CLASSAB_NULL_Pin_3 GNDA VDDA VINN VINP VOUT
     M29 (VOUT net13 GNDA GNDA) nch_18_mac l=MOSFET_29_1_L_gm3_NMOS w=MOSFET_29_1_W_gm3_NMOS*1 multi=MOSFET_29_1_M_gm3_NMOS nf=1
     M27 (net17 net1 GNDA GNDA) nch_18_mac l=MOSFET_0_1_L_BIASCM_NMOS w=MOSFET_0_1_W_BIASCM_NMOS*1 multi=MOSFET_0_1_M_BIASCM_NMOS nf=1
     M24 (net16 net16 GNDA GNDA) nch_18_mac l=MOSFET_21_1_L_BIASCM_NMOS w=MOSFET_21_1_W_BIASCM_NMOS*1 multi=MOSFET_21_1_M_BIASCM_NMOS nf=1
     M23 (net15 net15 net16 GNDA) nch_18_mac l=MOSFET_21_1_L_BIASCM_NMOS w=MOSFET_21_1_W_BIASCM_NMOS*1 multi=MOSFET_21_1_M_BIASCM_NMOS nf=1
     M21 (net12 net15 net13 GNDA) nch_18_mac l=MOSFET_21_1_L_BIASCM_NMOS w=MOSFET_21_1_W_BIASCM_NMOS*1 multi=MOSFET_21_1_M_BIASCM_NMOS nf=1
     M20 (net14 net5 GNDA GNDA) nch_18_mac l=MOSFET_12_1_L_gm2_NMOS w=MOSFET_12_1_W_gm2_NMOS*1 multi=MOSFET_12_1_M_gm2_NMOS nf=1
     M19 (net13 net19 net14 GNDA) nch_18_mac l=MOSFET_13_1_L_BIASCM_NMOS w=MOSFET_13_1_W_BIASCM_NMOS*1 multi=MOSFET_13_1_M_BIASCM_NMOS nf=1
     M13 (net9 net19 net8 GNDA) nch_18_mac l=MOSFET_13_1_L_BIASCM_NMOS w=MOSFET_13_1_W_BIASCM_NMOS*1 multi=MOSFET_13_1_M_BIASCM_NMOS nf=1
     M12 (net8 net7 GNDA GNDA) nch_18_mac l=MOSFET_12_1_L_gm2_NMOS w=MOSFET_12_1_W_gm2_NMOS*1 multi=MOSFET_12_1_M_gm2_NMOS nf=1
     M5 (net7 net6 GNDA GNDA) nch_18_mac l=MOSFET_4_1_L_LOAD_NMOS w=MOSFET_4_1_W_LOAD_NMOS*1 multi=MOSFET_4_1_M_LOAD_NMOS nf=1
     M4 (net5 net6 GNDA GNDA) nch_18_mac l=MOSFET_4_1_L_LOAD_NMOS w=MOSFET_4_1_W_LOAD_NMOS*1 multi=MOSFET_4_1_M_LOAD_NMOS nf=1
     M3 (GNDA net19 GNDA GNDA) nch_18_mac l=150n w=320n multi=1 nf=1
     M2 (GNDA net1 GNDA GNDA) nch_18_mac l=150n w=320n multi=1 nf=1
     M1 (net2 net1 GNDA GNDA) nch_18_mac l=MOSFET_0_1_L_BIASCM_NMOS w=MOSFET_0_1_W_BIASCM_NMOS*1 multi=MOSFET_0_1_M_BIASCM_NMOS nf=1
     M0 (net1 net1 GNDA GNDA) nch_18_mac l=MOSFET_0_1_L_BIASCM_NMOS w=MOSFET_0_1_W_BIASCM_NMOS*1 multi=MOSFET_0_1_M_BIASCM_NMOS nf=1
     I0 (VDDA net19) isource dc=CURRENT_0_BIAS type=dc
     M28 (VOUT net12 VDDA VDDA) pch_18_mac l=MOSFET_28_1_L_gm3_PMOS w=MOSFET_28_1_W_gm3_PMOS*1 multi=MOSFET_28_1_M_gm3_PMOS nf=1
     M26 (net17 net17 net18 VDDA) pch_18_mac l=MOSFET_18_1_L_BIASCM_PMOS w=MOSFET_18_1_W_BIASCM_PMOS*1 multi=MOSFET_18_1_M_BIASCM_PMOS nf=1
     M25 (net18 net18 VDDA VDDA) pch_18_mac l=MOSFET_18_1_L_BIASCM_PMOS w=MOSFET_18_1_W_BIASCM_PMOS*1 multi=MOSFET_18_1_M_BIASCM_PMOS nf=1
     M22 (net15 net3 VDDA VDDA) pch_18_mac l=MOSFET_22_1_L_BIASCM_PMOS w=MOSFET_22_1_W_BIASCM_PMOS*1 multi=MOSFET_22_1_M_BIASCM_PMOS nf=1
     M18 (net13 net17 net12 VDDA) pch_18_mac l=MOSFET_18_1_L_BIASCM_PMOS w=MOSFET_18_1_W_BIASCM_PMOS*1 multi=MOSFET_18_1_M_BIASCM_PMOS nf=1
     M17 (net12 net2 net11 VDDA) pch_18_mac l=MOSFET_15_1_L_BIASCM_PMOS w=MOSFET_15_1_W_BIASCM_PMOS*1 multi=MOSFET_15_1_M_BIASCM_PMOS nf=1
     M16 (net11 net9 VDDA VDDA) pch_18_mac l=MOSFET_14_1_L_BIASCM_PMOS w=MOSFET_14_1_W_BIASCM_PMOS*1 multi=MOSFET_14_1_M_BIASCM_PMOS nf=1
     M15 (net9 net2 net10 VDDA) pch_18_mac l=MOSFET_15_1_L_BIASCM_PMOS w=MOSFET_15_1_W_BIASCM_PMOS*1 multi=MOSFET_15_1_M_BIASCM_PMOS nf=1
     M14 (net10 net9 VDDA VDDA) pch_18_mac l=MOSFET_14_1_L_BIASCM_PMOS w=MOSFET_14_1_W_BIASCM_PMOS*1 multi=MOSFET_14_1_M_BIASCM_PMOS nf=1
     M11 (net7 VINP net4 net4) pch_18_mac l=MOSFET_10_1_L_gm1_PMOS w=MOSFET_10_1_W_gm1_PMOS*1 multi=MOSFET_10_1_M_gm1_PMOS nf=1
     M10 (net5 VINN net4 net4) pch_18_mac l=MOSFET_10_1_L_gm1_PMOS w=MOSFET_10_1_W_gm1_PMOS*1 multi=MOSFET_10_1_M_gm1_PMOS nf=1
     M9 (VDDA net2 VDDA VDDA) pch_18_mac l=150n w=320n multi=1 nf=1
     M8 (VDDA net3 VDDA VDDA) pch_18_mac l=150n w=320n multi=1 nf=1
     M7 (net4 net3 VDDA VDDA) pch_18_mac l=MOSFET_6_1_L_BIASCM_PMOS w=MOSFET_6_1_W_BIASCM_PMOS*1 multi=6*MOSFET_6_1_M_BIASCM_NMOS nf=1
     M6 (net3 net3 VDDA VDDA) pch_18_mac l=MOSFET_6_1_L_BIASCM_PMOS w=MOSFET_6_1_W_BIASCM_PMOS*1 multi=MOSFET_6_1_M_BIASCM_PMOS nf=1
     R2 (net5 net6) resistor r=RESISTOR_1
     R3 (net6 net7) resistor r=RESISTOR_1
     R0 (net19 net1) resistor r=RESISTOR_0
     R1 (net3 net2) resistor r=RESISTOR_0
 ends CLASSAB_NULL_Pin_3
 // Library name: 2025_5_DCDC_TO
 // Cell name: TB_CLASSAB_NULL_Pin_3
 // View name: schematic
 V8 (VDD_PSRR 0) vsource dc=VDD mag=1 type=dc
 V7 (VIN_P_PSRR 0) vsource dc=VCM mag=0 phase=0 type=dc
 V6 (VIN_P_CMRR_TB net17) vsource dc=0 mag=1 phase=0 type=dc
 V5 (VIN_M_CMRR_TB VOUT_CMRR_TB) vsource dc=0 mag=1 phase=0 type=dc
 V3 (net17 0) vsource dc=VCM mag=0 phase=0 type=dc
 V2 (VINP 0) vsource dc=VCM mag=1 phase=0 type=dc
 V0 (VDD 0) vsource dc=VDD type=dc
 C2 (VOUT_PSRR 0) capacitor c=CLOAD
 C1 (VOUT_CMRR_TB 0) capacitor c=CLOAD
 C0 (VOUT 0) capacitor c=CLOAD
 I35 (0 VDD VIN_M VINP VOUT) CLASSAB_NULL_Pin_3
 I34 (0 VDD_PSRR VIN_M_PSRR VIN_P_PSRR VOUT_PSRR) CLASSAB_NULL_Pin_3
 I33 (0 VDD VIN_M_CMRR_TB VIN_P_CMRR_TB VOUT_CMRR_TB) CLASSAB_NULL_Pin_3
 IPRB2 (VOUT_PSRR VIN_M_PSRR) iprobe
 IPRB0 (VOUT VIN_M) iprobe
simulatorOptions options temp=-25
 ac ac start=0.1 stop=10G
 stb stb start=0.01 stop=100G probe=IPRB0 localgnd=0
 dcOp dc
 dc dc param=temp start=-50 stop=150
 noise ( VOUT 0 ) noise start=1 stop=10G iprobe=V2 annotate=status
 pz ( VOUT 0 ) pz iprobe=V2 freq=1 param=VCM start=0.5 stop=0.7
 save VOUT VINP VOUT_CMRR_TB VOUT_PSRR V8:n
saveOptions options save=selected

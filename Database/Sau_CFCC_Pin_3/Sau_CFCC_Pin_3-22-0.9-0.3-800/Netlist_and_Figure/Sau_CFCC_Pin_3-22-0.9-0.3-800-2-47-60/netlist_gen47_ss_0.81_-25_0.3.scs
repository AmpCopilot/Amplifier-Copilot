 // Design library name: TSMC22ULL_Std_AMP_LIB
 // Design cell name: TB_Sau_CFCC_Pin_3
 simulator lang=spectre
 global 0
 parameters _EXPR_2=PULSE_WIDTH*10+1u MOSFET_0_8_L_BIASCM_PMOS=0.834u MOSFET_0_8_M_BIASCM_PMOS=1.0 MOSFET_0_8_W_BIASCM_PMOS=0.668u MOSFET_10_1_L_gm2_PMOS=0.216u MOSFET_10_1_M_gm2_PMOS=3.0 MOSFET_10_1_W_gm2_PMOS=0.641u MOSFET_11_1_L_gmf2_PMOS=0.48u MOSFET_11_1_M_gmf2_PMOS=4.0 MOSFET_11_1_W_gmf2_PMOS=0.752u MOSFET_15_2_L_gmc_NMOS=0.237u MOSFET_15_2_M_gmc_NMOS=16.0 MOSFET_15_2_W_gmc_NMOS=1.0u MOSFET_17_7_L_BIASCM_NMOS=0.476u MOSFET_17_7_M_BIASCM_NMOS=1.0 MOSFET_17_7_W_BIASCM_NMOS=0.907u MOSFET_21_2_L_LOAD2_NMOS=0.679u MOSFET_21_2_M_LOAD2_NMOS=30.0 MOSFET_21_2_W_LOAD2_NMOS=0.1u MOSFET_23_1_L_gm3_NMOS=0.418u MOSFET_23_1_M_gm3_NMOS=2.0 MOSFET_23_1_W_gm3_NMOS=0.935u MOSFET_7_1_L_gmf1_PMOS=0.53u MOSFET_7_1_M_gmf1_PMOS=25.0 MOSFET_7_1_W_gmf1_PMOS=0.99u MOSFET_8_2_L_gm1_PMOS=0.242u MOSFET_8_2_M_gm1_PMOS=42.0 MOSFET_8_2_W_gm1_PMOS=0.217u CAPACITOR_0=1.15p CURRENT_0_BIAS=0.501u CLOAD=800p VCM=0.3 VDD=0.81
 include "/home/soc/zhihc21/7_Amp_complier/FAST_20240508/src/model/spectre_22model/crn22ull_1d8_elk_v1d3_1p1_shrink0d855_embedded_usage.scs" section=ssMacro_MOS_MOSCAP
include "/home/soc/zhihc21/7_Amp_complier/FAST_20240508/src/model/spectre_22model/crn22ull_1d8_elk_v1d3_1p1_shrink0d855_embedded_usage.scs" section=pre_simu
// Library name: TSMC22ULL_Std_AMP_LIB
 // Cell name: Sau_CFCC_Pin_3
 // View name: schematic
 subckt Sau_CFCC_Pin_3 GNDA VDDA VINN VINP VOUT
     M11 (VOUT net050 VDDA VDDA) pch_ulvt_mac l=MOSFET_11_1_L_gmf2_PMOS w=MOSFET_11_1_W_gmf2_PMOS*1 multi=MOSFET_11_1_M_gmf2_PMOS nf=1
     M7 (net049 VOUTN VDDA VDDA) pch_ulvt_mac l=MOSFET_7_1_L_gmf1_PMOS w=MOSFET_7_1_W_gmf1_PMOS*1 multi=MOSFET_7_1_M_gmf1_PMOS nf=1
     M10 (net043 net050 VDDA VDDA) pch_ulvt_mac l=MOSFET_10_1_L_gm2_PMOS w=MOSFET_10_1_W_gm2_PMOS*1 multi=MOSFET_10_1_M_gm2_PMOS nf=1
     M6 (net050 VOUTN VDDA VDDA) pch_ulvt_mac l=MOSFET_0_8_L_BIASCM_PMOS w=MOSFET_0_8_W_BIASCM_PMOS*1 multi=MOSFET_0_8_M_BIASCM_PMOS nf=1
     M5 (VOUTN VOUTN VDDA VDDA) pch_ulvt_mac l=MOSFET_0_8_L_BIASCM_PMOS w=MOSFET_0_8_W_BIASCM_PMOS*1 multi=MOSFET_0_8_M_BIASCM_PMOS nf=1
     M9 (net063 VINP net31 net31) pch_ulvt_mac l=MOSFET_8_2_L_gm1_PMOS w=MOSFET_8_2_W_gm1_PMOS*1 multi=MOSFET_8_2_M_gm1_PMOS nf=1
     M8 (DM_2 VINN net31 net31) pch_ulvt_mac l=MOSFET_8_2_L_gm1_PMOS w=MOSFET_8_2_W_gm1_PMOS*1 multi=MOSFET_8_2_M_gm1_PMOS nf=1
     M4 (net31 net013 VDDA VDDA) pch_ulvt_mac l=MOSFET_0_8_L_BIASCM_PMOS w=MOSFET_0_8_W_BIASCM_PMOS*1 multi=2*MOSFET_0_8_M_BIASCM_PMOS nf=1
     M3 (VB3 net013 VDDA VDDA) pch_ulvt_mac l=MOSFET_0_8_L_BIASCM_PMOS w=MOSFET_0_8_W_BIASCM_PMOS*1 multi=MOSFET_0_8_M_BIASCM_PMOS nf=1
     M2 (DM_1 net013 VDDA VDDA) pch_ulvt_mac l=MOSFET_0_8_L_BIASCM_PMOS w=MOSFET_0_8_W_BIASCM_PMOS*1 multi=MOSFET_0_8_M_BIASCM_PMOS nf=1
     M1 (VB4 net013 VDDA VDDA) pch_ulvt_mac l=MOSFET_0_8_L_BIASCM_PMOS w=MOSFET_0_8_W_BIASCM_PMOS*1 multi=MOSFET_0_8_M_BIASCM_PMOS nf=1
     M0 (net013 net013 VDDA VDDA) pch_ulvt_mac l=MOSFET_0_8_L_BIASCM_PMOS w=MOSFET_0_8_W_BIASCM_PMOS*1 multi=MOSFET_0_8_M_BIASCM_PMOS nf=1
     M23 (VOUT net049 GNDA GNDA) nch_ulvt_mac l=MOSFET_23_1_L_gm3_NMOS w=MOSFET_23_1_W_gm3_NMOS*1 multi=MOSFET_23_1_M_gm3_NMOS nf=1
     M22 (net049 net043 GNDA GNDA) nch_ulvt_mac l=MOSFET_21_2_L_LOAD2_NMOS w=MOSFET_21_2_W_LOAD2_NMOS*1 multi=MOSFET_21_2_M_LOAD2_NMOS*3 nf=1
     M21 (net043 net043 GNDA GNDA) nch_ulvt_mac l=MOSFET_21_2_L_LOAD2_NMOS w=MOSFET_21_2_W_LOAD2_NMOS*1 multi=MOSFET_21_2_M_LOAD2_NMOS nf=1
     M19 (DM_2 VB4 GNDA GNDA) nch_ulvt_mac l=MOSFET_17_7_L_BIASCM_NMOS w=MOSFET_17_7_W_BIASCM_NMOS*1 multi=MOSFET_17_7_M_BIASCM_NMOS*8 nf=1
     M15 (VOUTN VB3 DM_2 GNDA) nch_ulvt_mac l=MOSFET_15_2_L_gmc_NMOS w=MOSFET_15_2_W_gmc_NMOS*1 multi=MOSFET_15_2_M_gmc_NMOS*1 nf=1
     M20 (net063 VB4 GNDA GNDA) nch_ulvt_mac l=MOSFET_17_7_L_BIASCM_NMOS w=MOSFET_17_7_W_BIASCM_NMOS*1 multi=MOSFET_17_7_M_BIASCM_NMOS*8 nf=1
     M16 (net050 VB3 net063 GNDA) nch_ulvt_mac l=MOSFET_15_2_L_gmc_NMOS w=MOSFET_15_2_W_gmc_NMOS*1 multi=MOSFET_15_2_M_gmc_NMOS*1 nf=1
     M17 (net54 VB4 GNDA GNDA) nch_ulvt_mac l=MOSFET_17_7_L_BIASCM_NMOS w=MOSFET_17_7_W_BIASCM_NMOS*1 multi=MOSFET_17_7_M_BIASCM_NMOS*4 nf=1
     M14 (VB3 VB3 GNDA GNDA) nch_ulvt_mac l=MOSFET_17_7_L_BIASCM_NMOS w=MOSFET_17_7_W_BIASCM_NMOS*1 multi=MOSFET_17_7_M_BIASCM_NMOS nf=1
     M12 (VB4 VB3 net54 GNDA) nch_ulvt_mac l=MOSFET_17_7_L_BIASCM_NMOS w=MOSFET_17_7_W_BIASCM_NMOS*1 multi=MOSFET_17_7_M_BIASCM_NMOS*4 nf=1
     M18 (net56 VB4 GNDA GNDA) nch_ulvt_mac l=MOSFET_17_7_L_BIASCM_NMOS w=MOSFET_17_7_W_BIASCM_NMOS*1 multi=MOSFET_17_7_M_BIASCM_NMOS*4 nf=1
     M13 (DM_1 VB3 net56 GNDA) nch_ulvt_mac l=MOSFET_17_7_L_BIASCM_NMOS w=MOSFET_17_7_W_BIASCM_NMOS*1 multi=MOSFET_17_7_M_BIASCM_NMOS*4 nf=1
     I0 (net013 GNDA) isource dc=CURRENT_0_BIAS type=dc
     C0 (net063 VOUT) capacitor c=CAPACITOR_0
 ends Sau_CFCC_Pin_3
 // Library name: TSMC22ULL_Std_AMP_LIB
 // Cell name: TB_Sau_CFCC_Pin_3
 // View name: schematic
 V8 (VDD_PSRR 0) vsource dc=VDD mag=1 type=dc
 V7 (VIN_P_PSRR 0) vsource dc=VCM mag=0 phase=0 type=dc
 V6 (VIN_P_CMRR_TB net17) vsource dc=0 mag=1 phase=0 type=dc
 V5 (VIN_M_CMRR_TB VOUT_CMRR_TB) vsource dc=0 mag=1 phase=0 type=dc
 V3 (net17 0) vsource dc=VCM mag=0 phase=0 type=dc
 V2 (VINP 0) vsource dc=VCM mag=1 phase=0 type=dc
 V0 (VDD 0) vsource dc=VDD type=dc
 C2 (VOUT_PSRR 0) capacitor c=CLOAD
 C1 (VOUT_CMRR_TB 0) capacitor c=CLOAD
 C0 (VOUT 0) capacitor c=CLOAD
 I29 (0 VDD VIN_M VINP VOUT) Sau_CFCC_Pin_3
 I28 (0 VDD_PSRR VIN_M_PSRR VIN_P_PSRR VOUT_PSRR) Sau_CFCC_Pin_3
 I27 (0 VDD VIN_M_CMRR_TB VIN_P_CMRR_TB VOUT_CMRR_TB) Sau_CFCC_Pin_3
 IPRB2 (VOUT_PSRR VIN_M_PSRR) iprobe
 IPRB0 (VOUT VIN_M) iprobe
simulatorOptions options temp=-25
 ac ac start=0.1 stop=10G
 stb stb start=0.01 stop=100G probe=IPRB0 localgnd=0
 dcOp dc
 dc dc param=temp start=-50 stop=150
 noise ( VOUT 0 ) noise start=1 stop=10G iprobe=V2 annotate=status
 pz ( VOUT 0 ) pz iprobe=V2 freq=1 param=VCM start=0 stop=600m
 save VOUT VINP VOUT_CMRR_TB VOUT_PSRR V8:n
saveOptions options save=selected

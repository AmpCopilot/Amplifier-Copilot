 // Design library name: TSMC22ULL_Std_AMP_LIB
 // Design cell name: TB_R2R_Miller_PNin_2
 simulator lang=spectre
 global 0
 parameters _EXPR_2=PULSE_WIDTH*10+1u MOSFET_15_1_L_EXTCM_NMOS=0.8526548u MOSFET_15_1_M_EXTCM_NMOS=1.0 MOSFET_15_1_W_EXTCM_NMOS=0.5029021u MOSFET_16_1_L_EXTCM_PMOS=0.1336194u MOSFET_16_1_M_EXTCM_PMOS=1.0 MOSFET_16_1_W_EXTCM_PMOS=0.3709391u MOSFET_0_8_L_BIASCM_PMOS=1.437959u MOSFET_0_8_M_BIASCM_PMOS=10.0 MOSFET_0_8_W_BIASCM_PMOS=2.030091u MOSFET_17_7_L_BIASCM_NMOS=2.183173u MOSFET_17_7_M_BIASCM_NMOS=2.0 MOSFET_17_7_W_BIASCM_NMOS=1.378684u MOSFET_19_7_L_gm1_NMOS=5.684189u MOSFET_19_7_M_gm1_NMOS=50.0 MOSFET_19_7_W_gm1_NMOS=2.0u MOSFET_28_1_L_gm2_PMOS=0.3437997u MOSFET_28_1_M_gm2_PMOS=50.0 MOSFET_28_1_W_gm2_PMOS=2.008399u MOSFET_29_1_L_gm2_NMOS=1.042871u MOSFET_29_1_M_gm2_NMOS=13.0 MOSFET_29_1_W_gm2_NMOS=1.892893u MOSFET_4_1_L_gm1_PMOS=0.5136741u MOSFET_4_1_M_gm1_PMOS=13.0 MOSFET_4_1_W_gm1_PMOS=1.909384u CAPACITOR_0=8.984371p CURRENT_0_BIAS=6.853662u CLOAD=50p VCM=0.3 VDD=0.81
 include "/home/soc/zhihc21/7_Amp_complier/OTA_Compiler_251229/Process_Library/40nm_0p9V/models/crn40ulp_esf3_2d5_v1d2_2p1_shrink0d9_embedded_usage.scs" section=ssmacro_mos_moscap
include "/home/soc/zhihc21/7_Amp_complier/OTA_Compiler_251229/Process_Library/40nm_0p9V/models/crn40ulp_esf3_2d5_v1d2_2p1_shrink0d9_embedded_usage.scs" section=pre_simu
// Library name: TSMC22ULL_Std_AMP_LIB
 // Cell name: R2R_Miller_PNin_2
 // View name: schematic
 subckt R2R_Miller_PNin_2 GNDA VDDA VINN VINP VOUT
     I0 (VB1 GNDA) isource dc=CURRENT_0_BIAS type=dc
     M64 (net80 VB4 GNDA GNDA) nch_elvt_mac l=MOSFET_17_7_L_BIASCM_NMOS w=MOSFET_17_7_W_BIASCM_NMOS*1 multi=MOSFET_17_7_M_BIASCM_NMOS*4 nf=1
     M63 (VB2 VB3 net80 GNDA) nch_elvt_mac l=MOSFET_17_7_L_BIASCM_NMOS w=MOSFET_17_7_W_BIASCM_NMOS*1 multi=MOSFET_17_7_M_BIASCM_NMOS*4 nf=1
     M47 (net1 VB3 net8 GNDA) nch_elvt_mac l=MOSFET_17_7_L_BIASCM_NMOS w=MOSFET_17_7_W_BIASCM_NMOS*1 multi=MOSFET_17_7_M_BIASCM_NMOS*8 nf=1
     M46 (net7 VB3 net3 GNDA) nch_elvt_mac l=MOSFET_17_7_L_BIASCM_NMOS w=MOSFET_17_7_W_BIASCM_NMOS*1 multi=MOSFET_17_7_M_BIASCM_NMOS*8 nf=1
     M44 (net12 VB4 GNDA GNDA) nch_elvt_mac l=MOSFET_17_7_L_BIASCM_NMOS w=MOSFET_17_7_W_BIASCM_NMOS*1 multi=MOSFET_17_7_M_BIASCM_NMOS*2 nf=1
     M40 (net8 net7 GNDA GNDA) nch_elvt_mac l=MOSFET_17_7_L_BIASCM_NMOS w=MOSFET_17_7_W_BIASCM_NMOS*1 multi=MOSFET_17_7_M_BIASCM_NMOS*16 nf=1
     M39 (net3 net7 GNDA GNDA) nch_elvt_mac l=MOSFET_17_7_L_BIASCM_NMOS w=MOSFET_17_7_W_BIASCM_NMOS*1 multi=MOSFET_17_7_M_BIASCM_NMOS*16 nf=1
     M33 (net17 net10 net7 GNDA) nch_elvt_mac l=MOSFET_29_1_L_gm2_NMOS w=MOSFET_29_1_W_gm2_NMOS*1 multi=MOSFET_29_1_M_gm2_NMOS*2 nf=1
     M29 (VOUT net1 GNDA GNDA) nch_elvt_mac l=MOSFET_29_1_L_gm2_NMOS w=MOSFET_29_1_W_gm2_NMOS*1 multi=MOSFET_29_1_M_gm2_NMOS*10 nf=1
     M28 (net10 net10 net11 GNDA) nch_elvt_mac l=MOSFET_29_1_L_gm2_NMOS w=MOSFET_29_1_W_gm2_NMOS*1 multi=MOSFET_29_1_M_gm2_NMOS nf=1
     M26 (net2 net10 net1 GNDA) nch_elvt_mac l=MOSFET_29_1_L_gm2_NMOS w=MOSFET_29_1_W_gm2_NMOS*1 multi=MOSFET_29_1_M_gm2_NMOS nf=1
     M24 (net11 net11 GNDA GNDA) nch_elvt_mac l=MOSFET_29_1_L_gm2_NMOS w=MOSFET_29_1_W_gm2_NMOS*1 multi=MOSFET_29_1_M_gm2_NMOS nf=1
     M22 (net19 VB4 GNDA GNDA) nch_elvt_mac l=MOSFET_17_7_L_BIASCM_NMOS w=MOSFET_17_7_W_BIASCM_NMOS*1 multi=MOSFET_17_7_M_BIASCM_NMOS*8 nf=1
     M20 (net5 VINP net19 GNDA) nch_elvt_mac l=MOSFET_19_7_L_gm1_NMOS w=MOSFET_19_7_W_gm1_NMOS*1 multi=MOSFET_19_7_M_gm1_NMOS nf=1
     M19 (net6 VINN net19 GNDA) nch_elvt_mac l=MOSFET_19_7_L_gm1_NMOS w=MOSFET_19_7_W_gm1_NMOS*1 multi=MOSFET_19_7_M_gm1_NMOS nf=1
     M18 (net79 VB4 GNDA GNDA) nch_elvt_mac l=MOSFET_17_7_L_BIASCM_NMOS w=MOSFET_17_7_W_BIASCM_NMOS*1 multi=MOSFET_17_7_M_BIASCM_NMOS*4 nf=1
     M17 (net35 VB4 GNDA GNDA) nch_elvt_mac l=MOSFET_17_7_L_BIASCM_NMOS w=MOSFET_17_7_W_BIASCM_NMOS*1 multi=MOSFET_17_7_M_BIASCM_NMOS*4 nf=1
     M14 (VB3 VB3 GNDA GNDA) nch_elvt_mac l=MOSFET_17_7_L_BIASCM_NMOS w=MOSFET_17_7_W_BIASCM_NMOS*1 multi=MOSFET_17_7_M_BIASCM_NMOS nf=1
     M12 (VB4 VB3 net35 GNDA) nch_elvt_mac l=MOSFET_17_7_L_BIASCM_NMOS w=MOSFET_17_7_W_BIASCM_NMOS*1 multi=MOSFET_17_7_M_BIASCM_NMOS*4 nf=1
     M13 (net78 VB3 net79 GNDA) nch_elvt_mac l=MOSFET_17_7_L_BIASCM_NMOS w=MOSFET_17_7_W_BIASCM_NMOS*1 multi=MOSFET_17_7_M_BIASCM_NMOS*4 nf=1
     M15 (net14 VB3 net19 GNDA) nch_elvt_mac l=MOSFET_15_1_L_EXTCM_NMOS w=MOSFET_15_1_W_EXTCM_NMOS*1 multi=MOSFET_15_1_M_EXTCM_NMOS nf=1
     M11 (net19 net15 GNDA GNDA) nch_elvt_mac l=MOSFET_17_7_L_BIASCM_NMOS w=MOSFET_17_7_W_BIASCM_NMOS*1 multi=MOSFET_17_7_M_BIASCM_NMOS*12 nf=1
     M10 (net15 net15 GNDA GNDA) nch_elvt_mac l=MOSFET_17_7_L_BIASCM_NMOS w=MOSFET_17_7_W_BIASCM_NMOS*1 multi=MOSFET_17_7_M_BIASCM_NMOS*4 nf=1
     M65 (VB2 VB2 VDDA VDDA) pch_elvt_mac l=MOSFET_0_8_L_BIASCM_PMOS w=MOSFET_0_8_W_BIASCM_PMOS*1 multi=MOSFET_0_8_M_BIASCM_PMOS nf=1
     M62 (VB3 VB2 net58 VDDA) pch_elvt_mac l=MOSFET_0_8_L_BIASCM_PMOS w=MOSFET_0_8_W_BIASCM_PMOS*1 multi=MOSFET_0_8_M_BIASCM_PMOS*4 nf=1
     M61 (net78 VB2 net77 VDDA) pch_elvt_mac l=MOSFET_0_8_L_BIASCM_PMOS w=MOSFET_0_8_W_BIASCM_PMOS*1 multi=MOSFET_0_8_M_BIASCM_PMOS*4 nf=1
     M58 (VB4 VB2 net23 VDDA) pch_elvt_mac l=MOSFET_0_8_L_BIASCM_PMOS w=MOSFET_0_8_W_BIASCM_PMOS*1 multi=MOSFET_0_8_M_BIASCM_PMOS*4 nf=1
     M57 (VB1 VB2 net9 VDDA) pch_elvt_mac l=MOSFET_0_8_L_BIASCM_PMOS w=MOSFET_0_8_W_BIASCM_PMOS*1 multi=MOSFET_0_8_M_BIASCM_PMOS*4 nf=1
     M49 (net6 net17 VDDA VDDA) pch_elvt_mac l=MOSFET_0_8_L_BIASCM_PMOS w=MOSFET_0_8_W_BIASCM_PMOS*1 multi=MOSFET_0_8_M_BIASCM_PMOS*16 nf=1
     M48 (net5 net17 VDDA VDDA) pch_elvt_mac l=MOSFET_0_8_L_BIASCM_PMOS w=MOSFET_0_8_W_BIASCM_PMOS*1 multi=MOSFET_0_8_M_BIASCM_PMOS*16 nf=1
     M45 (net7 net12 net17 VDDA) pch_elvt_mac l=MOSFET_28_1_L_gm2_PMOS w=MOSFET_28_1_W_gm2_PMOS*1 multi=MOSFET_28_1_M_gm2_PMOS*2 nf=1
     M43 (net17 VB2 net6 VDDA) pch_elvt_mac l=MOSFET_0_8_L_BIASCM_PMOS w=MOSFET_0_8_W_BIASCM_PMOS*1 multi=MOSFET_0_8_M_BIASCM_PMOS*8 nf=1
     M42 (net2 VB2 net5 VDDA) pch_elvt_mac l=MOSFET_0_8_L_BIASCM_PMOS w=MOSFET_0_8_W_BIASCM_PMOS*1 multi=MOSFET_0_8_M_BIASCM_PMOS*8 nf=1
     M41 (net10 VB1 VDDA VDDA) pch_elvt_mac l=MOSFET_0_8_L_BIASCM_PMOS w=MOSFET_0_8_W_BIASCM_PMOS*1 multi=MOSFET_0_8_M_BIASCM_PMOS*2 nf=1
     M38 (net13 net13 VDDA VDDA) pch_elvt_mac l=MOSFET_28_1_L_gm2_PMOS w=MOSFET_28_1_W_gm2_PMOS*1 multi=MOSFET_28_1_M_gm2_PMOS nf=1
     M32 (VOUT net2 VDDA VDDA) pch_elvt_mac l=MOSFET_28_1_L_gm2_PMOS w=MOSFET_28_1_W_gm2_PMOS*1 multi=MOSFET_28_1_M_gm2_PMOS*10 nf=1
     M31 (net12 net12 net13 VDDA) pch_elvt_mac l=MOSFET_28_1_L_gm2_PMOS w=MOSFET_28_1_W_gm2_PMOS*1 multi=MOSFET_28_1_M_gm2_PMOS nf=1
     M30 (net1 net12 net2 VDDA) pch_elvt_mac l=MOSFET_28_1_L_gm2_PMOS w=MOSFET_28_1_W_gm2_PMOS*1 multi=MOSFET_28_1_M_gm2_PMOS nf=1
     M21 (net18 VB1 VDDA VDDA) pch_elvt_mac l=MOSFET_0_8_L_BIASCM_PMOS w=MOSFET_0_8_W_BIASCM_PMOS*1 multi=MOSFET_0_8_M_BIASCM_PMOS*8 nf=1
     M16 (net15 VB2 net18 VDDA) pch_elvt_mac l=MOSFET_16_1_L_EXTCM_PMOS w=MOSFET_16_1_W_EXTCM_PMOS*1 multi=MOSFET_16_1_M_EXTCM_PMOS nf=1
     M3 (net58 VB1 VDDA VDDA) pch_elvt_mac l=MOSFET_0_8_L_BIASCM_PMOS w=MOSFET_0_8_W_BIASCM_PMOS*1 multi=MOSFET_0_8_M_BIASCM_PMOS*4 nf=1
     M2 (net77 VB1 VDDA VDDA) pch_elvt_mac l=MOSFET_0_8_L_BIASCM_PMOS w=MOSFET_0_8_W_BIASCM_PMOS*1 multi=MOSFET_0_8_M_BIASCM_PMOS*4 nf=1
     M1 (net23 VB1 VDDA VDDA) pch_elvt_mac l=MOSFET_0_8_L_BIASCM_PMOS w=MOSFET_0_8_W_BIASCM_PMOS*1 multi=MOSFET_0_8_M_BIASCM_PMOS*4 nf=1
     M5 (net8 VINP net18 net18) pch_elvt_mac l=MOSFET_4_1_L_gm1_PMOS w=MOSFET_4_1_W_gm1_PMOS*1 multi=MOSFET_4_1_M_gm1_PMOS nf=1
     M4 (net3 VINN net18 net18) pch_elvt_mac l=MOSFET_4_1_L_gm1_PMOS w=MOSFET_4_1_W_gm1_PMOS*1 multi=MOSFET_4_1_M_gm1_PMOS nf=1
     M7 (net18 net14 VDDA VDDA) pch_elvt_mac l=MOSFET_0_8_L_BIASCM_PMOS w=MOSFET_0_8_W_BIASCM_PMOS*1 multi=MOSFET_0_8_M_BIASCM_PMOS*12 nf=1
     M8 (net14 net14 VDDA VDDA) pch_elvt_mac l=MOSFET_0_8_L_BIASCM_PMOS w=MOSFET_0_8_W_BIASCM_PMOS*1 multi=MOSFET_0_8_M_BIASCM_PMOS*4 nf=1
     M0 (net9 VB1 VDDA VDDA) pch_elvt_mac l=MOSFET_0_8_L_BIASCM_PMOS w=MOSFET_0_8_W_BIASCM_PMOS*1 multi=MOSFET_0_8_M_BIASCM_PMOS*4 nf=1
     C1 (net2 VOUT) capacitor c=CAPACITOR_0
     C0 (net1 VOUT) capacitor c=CAPACITOR_0
 ends R2R_Miller_PNin_2
 // Library name: TSMC22ULL_Std_AMP_LIB
 // Cell name: TB_R2R_Miller_PNin_2
 // View name: schematic
 V8 (VDD_PSRR 0) vsource dc=VDD mag=1 type=dc
 V7 (VIN_P_PSRR 0) vsource dc=VCM mag=0 phase=0 type=dc
 V6 (VIN_P_CMRR_TB net17) vsource dc=0 mag=1 phase=0 type=dc
 V5 (VIN_M_CMRR_TB VOUT_CMRR_TB) vsource dc=0 mag=1 phase=0 type=dc
 V3 (net17 0) vsource dc=VCM mag=0 phase=0 type=dc
 V2 (VINP 0) vsource dc=VCM mag=1 phase=0 type=dc
 V0 (VDD 0) vsource dc=VDD type=dc
 C2 (VOUT_PSRR 0) capacitor c=CLOAD
 C1 (VOUT_CMRR_TB 0) capacitor c=CLOAD
 C0 (VOUT 0) capacitor c=CLOAD
 I32 (0 VDD VIN_M VINP VOUT) R2R_Miller_PNin_2
 I31 (0 VDD_PSRR VIN_M_PSRR VIN_P_PSRR VOUT_PSRR) R2R_Miller_PNin_2
 I30 (0 VDD VIN_M_CMRR_TB VIN_P_CMRR_TB VOUT_CMRR_TB) R2R_Miller_PNin_2
 IPRB2 (VOUT_PSRR VIN_M_PSRR) iprobe
 IPRB0 (VOUT VIN_M) iprobe
simulatorOptions options temp=-25
 ac ac start=0.1 stop=10G
 stb stb start=0.01 stop=100G probe=IPRB0 localgnd=0
 dcOp dc
 dc dc param=VCM start=0 stop=VDD
 noise ( VOUT 0 ) noise start=1 stop=10G iprobe=V2 annotate=status
 pz ( VOUT 0 ) pz iprobe=V2 freq=1 param=VCM start=0 stop=100m lin=1
 save VOUT VINP VOUT_CMRR_TB VOUT_PSRR V8:n I32.M19:1 I32.M20:1 I32.M4:3 I32.M5:3 I32.M7:3 I32.M11:1
 save I32.M19:gm I32.M4:gm I32.M45:id I32.M45:gm I32.M33:id I32.M33:gm
saveOptions options save=selected

 // Design library name: TSMC22ULL_Std_AMP_LIB
 // Design cell name: TB_TRANPseudoTwoSt_Null_Pin_1
 simulator lang=spectre
 global 0
 parameters MOSFET_0_1_L_BIASCM0_PMOS=0.1u MOSFET_0_1_M_BIASCM0_PMOS=1.0 MOSFET_0_1_W_BIASCM0_PMOS=0.1u MOSFET_2_2_L_LOAD2_PMOS=0.1u MOSFET_2_2_M_LOAD2_PMOS=30 MOSFET_2_2_W_LOAD2_PMOS=1.0u MOSFET_3_2_L_gm1_PMOS=0.2u MOSFET_3_2_M_gm1_PMOS=4.0 MOSFET_3_2_W_gm1_PMOS=0.8u MOSFET_5_2_L_LOAD1_NMOS=0.2u MOSFET_5_2_M_LOAD1_NMOS=4.0 MOSFET_5_2_W_LOAD1_NMOS=0.9u MOSFET_7_1_L_gm2_NMOS=0.1u MOSFET_7_1_M_gm2_NMOS=30 MOSFET_7_1_W_gm2_NMOS=1.0u CURRENT_0_BIAS=180.7u CLOAD=0.05p VCM=0.3 VDD=0.81
 include "/home/soc/zhihc21/7_Amp_complier/OTA_Compiler_v260103_try/Process_Library/22nm_0p9V/models/crn22ull_1d8_elk_v1d3_1p1_shrink0d855_embedded_usage.scs" section=SSMacro_MOS_MOSCAP
include "/home/soc/zhihc21/7_Amp_complier/OTA_Compiler_v260103_try/Process_Library/22nm_0p9V/models/crn22ull_1d8_elk_v1d3_1p1_shrink0d855_embedded_usage.scs" section=pre_simu
// Library name: TSMC22ULL_Std_AMP_LIB
 // Cell name: PseudoTwoSt_Null_Pin_1
 // View name: schematic
 subckt PseudoTwoSt_Null_Pin_1 GNDA VDDA VINN VINP VOUT
     M9 (net3 net3 VDDA VDDA) pch_ulvt_mac l=MOSFET_2_2_L_LOAD2_PMOS w=MOSFET_2_2_W_LOAD2_PMOS*1 multi=MOSFET_2_2_M_LOAD2_PMOS nf=1
     M4 (OUTN VINP net22 net22) pch_ulvt_mac l=MOSFET_3_2_L_gm1_PMOS w=MOSFET_3_2_W_gm1_PMOS*1 multi=MOSFET_3_2_M_gm1_PMOS nf=1
     M3 (OUTP VINN net22 net22) pch_ulvt_mac l=MOSFET_3_2_L_gm1_PMOS w=MOSFET_3_2_W_gm1_PMOS*1 multi=MOSFET_3_2_M_gm1_PMOS nf=1
     M1 (net22 net1 VDDA VDDA) pch_ulvt_mac l=MOSFET_0_1_L_BIASCM0_PMOS w=MOSFET_0_1_W_BIASCM0_PMOS*1 multi=MOSFET_0_1_M_BIASCM0_PMOS*2 nf=1
     M2 (VOUT net3 VDDA VDDA) pch_ulvt_mac l=MOSFET_2_2_L_LOAD2_PMOS w=MOSFET_2_2_W_LOAD2_PMOS*1 multi=MOSFET_2_2_M_LOAD2_PMOS*1 nf=1
     M0 (net1 net1 VDDA VDDA) pch_ulvt_mac l=MOSFET_0_1_L_BIASCM0_PMOS w=MOSFET_0_1_W_BIASCM0_PMOS*1 multi=MOSFET_0_1_M_BIASCM0_PMOS nf=1
     I6 (net1 GNDA) isource dc=CURRENT_0_BIAS type=dc
     M8 (net3 OUTP GNDA GNDA) nch_ulvt_mac l=MOSFET_7_1_L_gm2_NMOS w=MOSFET_7_1_W_gm2_NMOS*1 multi=MOSFET_7_1_M_gm2_NMOS nf=1
     M7 (VOUT OUTN GNDA GNDA) nch_ulvt_mac l=MOSFET_7_1_L_gm2_NMOS w=MOSFET_7_1_W_gm2_NMOS*1 multi=MOSFET_7_1_M_gm2_NMOS nf=1
     M5 (OUTP OUTP GNDA GNDA) nch_ulvt_mac l=MOSFET_5_2_L_LOAD1_NMOS w=MOSFET_5_2_W_LOAD1_NMOS*1 multi=MOSFET_5_2_M_LOAD1_NMOS nf=1
     M6 (OUTN OUTN GNDA GNDA) nch_ulvt_mac l=MOSFET_5_2_L_LOAD1_NMOS w=MOSFET_5_2_W_LOAD1_NMOS*1 multi=MOSFET_5_2_M_LOAD1_NMOS nf=1
 ends PseudoTwoSt_Null_Pin_1
 // Library name: TSMC22ULL_Std_AMP_LIB
 // Cell name: TB_TRANPseudoTwoSt_Null_Pin_1
 // View name: schematic
 V0 (VDD 0) vsource dc=VDD type=dc
 C0 (SR_VOUT 0) capacitor c=CLOAD
 I17 (0 VDD SR_VOUT SR_VINP SR_VOUT) PseudoTwoSt_Null_Pin_1
 V1 (SR_VINP 0) vsource dc=0 type=pulse delay=1u edgetype=linear val0=0.1 val1=0.5 period=1 rise=1p fall=1p width=5.00e-07
simulatorOptions options temp=-15
 tran tran stop=2.00e-06
 save SR_VOUT SR_VINP
saveOptions options save=selected

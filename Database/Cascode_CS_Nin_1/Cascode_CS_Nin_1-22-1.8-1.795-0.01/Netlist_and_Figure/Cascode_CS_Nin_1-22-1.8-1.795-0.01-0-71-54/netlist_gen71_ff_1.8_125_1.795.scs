 // Design library name: 2025_5_DCDC_TO
 // Design cell name: TB_Cascode_CS_Nin_1
 simulator lang=spectre
 global 0
 parameters _EXPR_2=PULSE_WIDTH*10+1u MOSFET_21_1_L_BIASCM_NMOS=0.974u MOSFET_21_1_M_BIASCM_NMOS=5.0 MOSFET_21_1_W_BIASCM_NMOS=1.12u MOSFET_25_1_L_gm1_NMOS=0.153u MOSFET_25_1_M_gm1_NMOS=38.0 MOSFET_25_1_W_gm1_NMOS=0.658u MOSFET_6_1_L_BIASCM_PMOS=0.452u MOSFET_6_1_M_BIASCM_PMOS=6.0 MOSFET_6_1_W_BIASCM_PMOS=0.3u CURRENT_0_BIAS=32.0u CLOAD=0.01p VCM=1.795 VDD=1.8
 include "/home/soc/zhihc21/7_Amp_complier/FAST_20240508/src/model/spectre_22model/crn22ull_1d8_elk_v1d3_1p1_shrink0d855_embedded_usage.scs" section=ffMacro_MOS_MOSCAP
include "/home/soc/zhihc21/7_Amp_complier/FAST_20240508/src/model/spectre_22model/crn22ull_1d8_elk_v1d3_1p1_shrink0d855_embedded_usage.scs" section=pre_simu
// Library name: 2025_5_DCDC_TO
 // Cell name: Cascode_CS_Nin_1
 // View name: schematic
 subckt Cascode_CS_Nin_1 GNDA VDDA VINN VINP VOUT
     M21 (net6 net6 VDDA VDDA) pch_18_mac l=MOSFET_6_1_L_BIASCM_PMOS w=MOSFET_6_1_W_BIASCM_PMOS*1 multi=MOSFET_6_1_M_BIASCM_PMOS nf=1
     M18 (net11 net5 VDDA VDDA) pch_18_mac l=MOSFET_6_1_L_BIASCM_PMOS w=MOSFET_6_1_W_BIASCM_PMOS*1 multi=MOSFET_6_1_M_BIASCM_PMOS*4 nf=1
     M11 (net259 net6 net11 VDDA) pch_18_mac l=MOSFET_6_1_L_BIASCM_PMOS w=MOSFET_6_1_W_BIASCM_PMOS*1 multi=MOSFET_6_1_M_BIASCM_PMOS*4 nf=1
     M10 (net16 net6 net2 VDDA) pch_18_mac l=MOSFET_6_1_L_BIASCM_PMOS w=MOSFET_6_1_W_BIASCM_PMOS*1 multi=MOSFET_6_1_M_BIASCM_PMOS*4 nf=1
     M8 (net2 net5 VDDA VDDA) pch_18_mac l=MOSFET_6_1_L_BIASCM_PMOS w=MOSFET_6_1_W_BIASCM_PMOS*1 multi=MOSFET_6_1_M_BIASCM_PMOS*4 nf=1
     M7 (net5 net6 net15 VDDA) pch_18_mac l=MOSFET_6_1_L_BIASCM_PMOS w=MOSFET_6_1_W_BIASCM_PMOS*1 multi=MOSFET_6_1_M_BIASCM_PMOS*4 nf=1
     M6 (net15 net5 VDDA VDDA) pch_18_mac l=MOSFET_6_1_L_BIASCM_PMOS w=MOSFET_6_1_W_BIASCM_PMOS*1 multi=MOSFET_6_1_M_BIASCM_PMOS*4 nf=1
     M17 (VOUT net6 net12 VDDA) pch_18_mac l=MOSFET_6_1_L_BIASCM_PMOS w=MOSFET_6_1_W_BIASCM_PMOS*1 multi=MOSFET_6_1_M_BIASCM_PMOS*4 nf=1
     M15 (net1 net6 net10 VDDA) pch_18_mac l=MOSFET_6_1_L_BIASCM_PMOS w=MOSFET_6_1_W_BIASCM_PMOS*1 multi=MOSFET_6_1_M_BIASCM_PMOS*4 nf=1
     M16 (net12 net5 VDDA VDDA) pch_18_mac l=MOSFET_6_1_L_BIASCM_PMOS w=MOSFET_6_1_W_BIASCM_PMOS*1 multi=MOSFET_6_1_M_BIASCM_PMOS*8 nf=1
     M14 (net10 net5 VDDA VDDA) pch_18_mac l=MOSFET_6_1_L_BIASCM_PMOS w=MOSFET_6_1_W_BIASCM_PMOS*1 multi=MOSFET_6_1_M_BIASCM_PMOS*8 nf=1
     M32 (net9 net16 GNDA GNDA) nch_18_mac l=MOSFET_21_1_L_BIASCM_NMOS w=MOSFET_21_1_W_BIASCM_NMOS*1 multi=MOSFET_21_1_M_BIASCM_NMOS*4 nf=1
     M31 (net6 net259 net9 GNDA) nch_18_mac l=MOSFET_21_1_L_BIASCM_NMOS w=MOSFET_21_1_W_BIASCM_NMOS*1 multi=MOSFET_21_1_M_BIASCM_NMOS*4 nf=1
     M30 (net259 net259 GNDA GNDA) nch_18_mac l=MOSFET_21_1_L_BIASCM_NMOS w=MOSFET_21_1_W_BIASCM_NMOS*1 multi=MOSFET_21_1_M_BIASCM_NMOS nf=1
     M29 (net4 net16 GNDA GNDA) nch_18_mac l=MOSFET_21_1_L_BIASCM_NMOS w=MOSFET_21_1_W_BIASCM_NMOS*1 multi=MOSFET_21_1_M_BIASCM_NMOS*4 nf=1
     M28 (net16 net259 net4 GNDA) nch_18_mac l=MOSFET_21_1_L_BIASCM_NMOS w=MOSFET_21_1_W_BIASCM_NMOS*1 multi=MOSFET_21_1_M_BIASCM_NMOS*4 nf=1
     M26 (net12 VINN net13 net13) nch_18_mac l=MOSFET_25_1_L_gm1_NMOS w=MOSFET_25_1_W_gm1_NMOS*1 multi=MOSFET_25_1_M_gm1_NMOS nf=1
     M25 (net10 VINP net13 net13) nch_18_mac l=MOSFET_25_1_L_gm1_NMOS w=MOSFET_25_1_W_gm1_NMOS*1 multi=MOSFET_25_1_M_gm1_NMOS nf=1
     M24 (net13 net259 net14 GNDA) nch_18_mac l=MOSFET_21_1_L_BIASCM_NMOS w=MOSFET_21_1_W_BIASCM_NMOS*1 multi=MOSFET_21_1_M_BIASCM_NMOS*8 nf=1
     M23 (net14 net16 GNDA GNDA) nch_18_mac l=MOSFET_21_1_L_BIASCM_NMOS w=MOSFET_21_1_W_BIASCM_NMOS*1 multi=MOSFET_21_1_M_BIASCM_NMOS*8 nf=1
     M19 (VOUT net259 net3 GNDA) nch_18_mac l=MOSFET_21_1_L_BIASCM_NMOS w=MOSFET_21_1_W_BIASCM_NMOS*1 multi=MOSFET_21_1_M_BIASCM_NMOS*4 nf=1
     M13 (net1 net259 net7 GNDA) nch_18_mac l=MOSFET_21_1_L_BIASCM_NMOS w=MOSFET_21_1_W_BIASCM_NMOS*1 multi=MOSFET_21_1_M_BIASCM_NMOS*4 nf=1
     M20 (net3 net1 GNDA GNDA) nch_18_mac l=MOSFET_21_1_L_BIASCM_NMOS w=MOSFET_21_1_W_BIASCM_NMOS*1 multi=MOSFET_21_1_M_BIASCM_NMOS*4 nf=1
     M12 (net7 net1 GNDA GNDA) nch_18_mac l=MOSFET_21_1_L_BIASCM_NMOS w=MOSFET_21_1_W_BIASCM_NMOS*1 multi=MOSFET_21_1_M_BIASCM_NMOS*4 nf=1
     I0 (net5 GNDA) isource dc=CURRENT_0_BIAS type=dc
 ends Cascode_CS_Nin_1
 // Library name: 2025_5_DCDC_TO
 // Cell name: TB_Cascode_CS_Nin_1
 // View name: schematic
 V13 (net2 VOUT_PSRR) vsource dc=900.0m type=dc
 V12 (net1 VOUT) vsource dc=900.0m type=dc
 V8 (VDD_PSRR 0) vsource dc=VDD mag=1 type=dc
 V7 (VIN_P_PSRR 0) vsource dc=VCM mag=0 phase=0 type=dc
 V6 (VIN_P_CMRR_TB net17) vsource dc=0 mag=1 phase=0 type=dc
 V5 (VIN_M_CMRR_TB VOUT_CMRR_TB) vsource dc=900.0m mag=1 phase=0 type=dc
 V3 (net17 0) vsource dc=VCM mag=0 phase=0 type=dc
 V2 (VINP 0) vsource dc=VCM mag=1 phase=0 type=dc
 V0 (VDD 0) vsource dc=VDD type=dc
 C2 (VOUT_PSRR 0) capacitor c=CLOAD
 C1 (VOUT_CMRR_TB 0) capacitor c=CLOAD
 C0 (VOUT 0) capacitor c=CLOAD
 I38 (0 VDD VIN_M VINP VOUT) Cascode_CS_Nin_1
 I37 (0 VDD_PSRR VIN_M_PSRR VIN_P_PSRR VOUT_PSRR) Cascode_CS_Nin_1
 I36 (0 VDD VIN_M_CMRR_TB VIN_P_CMRR_TB VOUT_CMRR_TB) Cascode_CS_Nin_1
 IPRB2 (net2 VIN_M_PSRR) iprobe
 IPRB0 (net1 VIN_M) iprobe
simulatorOptions options temp=125
 ac ac start=0.1 stop=10G
 stb stb start=0.01 stop=100G probe=IPRB0 localgnd=0
 dcOp dc
 dc dc param=temp start=-50 stop=150
 noise ( VOUT 0 ) noise start=1 stop=10G iprobe=V2 annotate=status
 pz ( VOUT 0 ) pz iprobe=V2 freq=1 param=VCM start=900m stop=1800m
 save VOUT VINP VOUT_CMRR_TB VOUT_PSRR V8:n
saveOptions options save=selected

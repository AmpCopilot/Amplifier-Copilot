 // Design library name: 2025_5_DCDC_TO
 // Design cell name: TB_TRANCascode_CS_Nin_1
 simulator lang=spectre
 global 0
 parameters MOSFET_21_1_L_BIASCM_NMOS=0.974u MOSFET_21_1_M_BIASCM_NMOS=5.0 MOSFET_21_1_W_BIASCM_NMOS=1.12u MOSFET_25_1_L_gm1_NMOS=0.153u MOSFET_25_1_M_gm1_NMOS=38.0 MOSFET_25_1_W_gm1_NMOS=0.658u MOSFET_6_1_L_BIASCM_PMOS=0.452u MOSFET_6_1_M_BIASCM_PMOS=6.0 MOSFET_6_1_W_BIASCM_PMOS=0.3u CURRENT_0_BIAS=32.0u CLOAD=0.01p VCM=1.795 VDD=1.8
 include "/home/soc/zhihc21/7_Amp_complier/FAST_20240508/src/model/spectre_22model/crn22ull_1d8_elk_v1d3_1p1_shrink0d855_embedded_usage.scs" section=ffMacro_MOS_MOSCAP
include "/home/soc/zhihc21/7_Amp_complier/FAST_20240508/src/model/spectre_22model/crn22ull_1d8_elk_v1d3_1p1_shrink0d855_embedded_usage.scs" section=pre_simu
// Library name: 2025_5_DCDC_TO
 // Cell name: Cascode_CS_Nin_1
 // View name: schematic
 subckt Cascode_CS_Nin_1 GNDA VDDA VINN VINP VOUT
     M21 (net6 net6 VDDA VDDA) pch_18_mac l=MOSFET_6_1_L_BIASCM_PMOS w=MOSFET_6_1_W_BIASCM_PMOS*1 multi=MOSFET_6_1_M_BIASCM_PMOS nf=1
     M18 (net11 net5 VDDA VDDA) pch_18_mac l=MOSFET_6_1_L_BIASCM_PMOS w=MOSFET_6_1_W_BIASCM_PMOS*1 multi=MOSFET_6_1_M_BIASCM_PMOS*4 nf=1
     M11 (net259 net6 net11 VDDA) pch_18_mac l=MOSFET_6_1_L_BIASCM_PMOS w=MOSFET_6_1_W_BIASCM_PMOS*1 multi=MOSFET_6_1_M_BIASCM_PMOS*4 nf=1
     M10 (net16 net6 net2 VDDA) pch_18_mac l=MOSFET_6_1_L_BIASCM_PMOS w=MOSFET_6_1_W_BIASCM_PMOS*1 multi=MOSFET_6_1_M_BIASCM_PMOS*4 nf=1
     M8 (net2 net5 VDDA VDDA) pch_18_mac l=MOSFET_6_1_L_BIASCM_PMOS w=MOSFET_6_1_W_BIASCM_PMOS*1 multi=MOSFET_6_1_M_BIASCM_PMOS*4 nf=1
     M7 (net5 net6 net15 VDDA) pch_18_mac l=MOSFET_6_1_L_BIASCM_PMOS w=MOSFET_6_1_W_BIASCM_PMOS*1 multi=MOSFET_6_1_M_BIASCM_PMOS*4 nf=1
     M6 (net15 net5 VDDA VDDA) pch_18_mac l=MOSFET_6_1_L_BIASCM_PMOS w=MOSFET_6_1_W_BIASCM_PMOS*1 multi=MOSFET_6_1_M_BIASCM_PMOS*4 nf=1
     M17 (VOUT net6 net12 VDDA) pch_18_mac l=MOSFET_6_1_L_BIASCM_PMOS w=MOSFET_6_1_W_BIASCM_PMOS*1 multi=MOSFET_6_1_M_BIASCM_PMOS*4 nf=1
     M15 (net1 net6 net10 VDDA) pch_18_mac l=MOSFET_6_1_L_BIASCM_PMOS w=MOSFET_6_1_W_BIASCM_PMOS*1 multi=MOSFET_6_1_M_BIASCM_PMOS*4 nf=1
     M16 (net12 net5 VDDA VDDA) pch_18_mac l=MOSFET_6_1_L_BIASCM_PMOS w=MOSFET_6_1_W_BIASCM_PMOS*1 multi=MOSFET_6_1_M_BIASCM_PMOS*8 nf=1
     M14 (net10 net5 VDDA VDDA) pch_18_mac l=MOSFET_6_1_L_BIASCM_PMOS w=MOSFET_6_1_W_BIASCM_PMOS*1 multi=MOSFET_6_1_M_BIASCM_PMOS*8 nf=1
     M32 (net9 net16 GNDA GNDA) nch_18_mac l=MOSFET_21_1_L_BIASCM_NMOS w=MOSFET_21_1_W_BIASCM_NMOS*1 multi=MOSFET_21_1_M_BIASCM_NMOS*4 nf=1
     M31 (net6 net259 net9 GNDA) nch_18_mac l=MOSFET_21_1_L_BIASCM_NMOS w=MOSFET_21_1_W_BIASCM_NMOS*1 multi=MOSFET_21_1_M_BIASCM_NMOS*4 nf=1
     M30 (net259 net259 GNDA GNDA) nch_18_mac l=MOSFET_21_1_L_BIASCM_NMOS w=MOSFET_21_1_W_BIASCM_NMOS*1 multi=MOSFET_21_1_M_BIASCM_NMOS nf=1
     M29 (net4 net16 GNDA GNDA) nch_18_mac l=MOSFET_21_1_L_BIASCM_NMOS w=MOSFET_21_1_W_BIASCM_NMOS*1 multi=MOSFET_21_1_M_BIASCM_NMOS*4 nf=1
     M28 (net16 net259 net4 GNDA) nch_18_mac l=MOSFET_21_1_L_BIASCM_NMOS w=MOSFET_21_1_W_BIASCM_NMOS*1 multi=MOSFET_21_1_M_BIASCM_NMOS*4 nf=1
     M26 (net12 VINN net13 net13) nch_18_mac l=MOSFET_25_1_L_gm1_NMOS w=MOSFET_25_1_W_gm1_NMOS*1 multi=MOSFET_25_1_M_gm1_NMOS nf=1
     M25 (net10 VINP net13 net13) nch_18_mac l=MOSFET_25_1_L_gm1_NMOS w=MOSFET_25_1_W_gm1_NMOS*1 multi=MOSFET_25_1_M_gm1_NMOS nf=1
     M24 (net13 net259 net14 GNDA) nch_18_mac l=MOSFET_21_1_L_BIASCM_NMOS w=MOSFET_21_1_W_BIASCM_NMOS*1 multi=MOSFET_21_1_M_BIASCM_NMOS*8 nf=1
     M23 (net14 net16 GNDA GNDA) nch_18_mac l=MOSFET_21_1_L_BIASCM_NMOS w=MOSFET_21_1_W_BIASCM_NMOS*1 multi=MOSFET_21_1_M_BIASCM_NMOS*8 nf=1
     M19 (VOUT net259 net3 GNDA) nch_18_mac l=MOSFET_21_1_L_BIASCM_NMOS w=MOSFET_21_1_W_BIASCM_NMOS*1 multi=MOSFET_21_1_M_BIASCM_NMOS*4 nf=1
     M13 (net1 net259 net7 GNDA) nch_18_mac l=MOSFET_21_1_L_BIASCM_NMOS w=MOSFET_21_1_W_BIASCM_NMOS*1 multi=MOSFET_21_1_M_BIASCM_NMOS*4 nf=1
     M20 (net3 net1 GNDA GNDA) nch_18_mac l=MOSFET_21_1_L_BIASCM_NMOS w=MOSFET_21_1_W_BIASCM_NMOS*1 multi=MOSFET_21_1_M_BIASCM_NMOS*4 nf=1
     M12 (net7 net1 GNDA GNDA) nch_18_mac l=MOSFET_21_1_L_BIASCM_NMOS w=MOSFET_21_1_W_BIASCM_NMOS*1 multi=MOSFET_21_1_M_BIASCM_NMOS*4 nf=1
     I0 (net5 GNDA) isource dc=CURRENT_0_BIAS type=dc
 ends Cascode_CS_Nin_1
 // Library name: 2025_5_DCDC_TO
 // Cell name: TB_TRANCascode_CS_Nin_1
 // View name: schematic
 V0 (VDD 0) vsource dc=VDD type=dc
 C0 (SR_VOUT 0) capacitor c=CLOAD
 I19 (0 VDD SR_VOUT SR_VINP SR_VOUT) Cascode_CS_Nin_1
 V1 (SR_VINP 0) vsource dc=0 type=pulse delay=1u edgetype=linear val0=0.6 val1=1.2 period=1 rise=1p fall=1p width=1.10e-05
simulatorOptions options temp=125
 tran tran stop=2.29e-05 errpreset=conservative
 save SR_VINP SR_VOUT
saveOptions options save=selected

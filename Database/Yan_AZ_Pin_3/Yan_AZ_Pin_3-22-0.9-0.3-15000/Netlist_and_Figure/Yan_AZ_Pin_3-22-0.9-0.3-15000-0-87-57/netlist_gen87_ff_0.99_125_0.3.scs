 // Design library name: TSMC22ULL_Std_AMP_LIB
 // Design cell name: TB_Yan_AZ_Pin_3
 simulator lang=spectre
 global 0
 parameters _EXPR_2=PULSE_WIDTH*10+1u MOSFET_0_14_L_BIASCM_PMOS=0.132u MOSFET_0_14_M_BIASCM_PMOS=1.0 MOSFET_0_14_W_BIASCM_PMOS=0.694u MOSFET_11_1_L_gm2_PMOS=0.85u MOSFET_11_1_M_gm2_PMOS=23.0 MOSFET_11_1_W_gm2_PMOS=1.38u MOSFET_13_1_L_gmf2_PMOS=0.85u MOSFET_13_1_M_gmf2_PMOS=114.0 MOSFET_13_1_W_gmf2_PMOS=0.1u MOSFET_14_4_L_gm8_NMOS=0.85u MOSFET_14_4_M_gm8_NMOS=10.0 MOSFET_14_4_W_gm8_NMOS=0.267u MOSFET_16_4_L_gm5_NMOS=0.565u MOSFET_16_4_M_gm5_NMOS=16.0 MOSFET_16_4_W_gm5_NMOS=1.73u MOSFET_18_1_L_gm3_NMOS=0.452u MOSFET_18_1_M_gm3_NMOS=5.0 MOSFET_18_1_W_gm3_NMOS=1.01u MOSFET_19_16_L_BIASCM_NMOS=0.288u MOSFET_19_16_M_BIASCM_NMOS=13.0 MOSFET_19_16_W_BIASCM_NMOS=0.698u MOSFET_22_1_L_gmb1_NMOS=0.85u MOSFET_22_1_M_gmb1_NMOS=17.0 MOSFET_22_1_W_gmb1_NMOS=1.1u MOSFET_23_1_L_gmb2_NMOS=0.369u MOSFET_23_1_M_gmb2_NMOS=4.0 MOSFET_23_1_W_gmb2_NMOS=0.255u MOSFET_9_2_L_gm1_PMOS=0.356u MOSFET_9_2_M_gm1_PMOS=5.0 MOSFET_9_2_W_gm1_PMOS=0.841u CURRENT_1_BIAS=3.77u RESISTOR_0=240.0k RESISTOR_1=85.7k RESISTOR_2=85.7k CAPACITOR_0=1.22p CAPACITOR_1=1.42p CLOAD=15000p VCM=0.3 VDD=0.99
 include "/home/soc/zhihc21/7_Amp_complier/FAST_20240508/src/model/spectre_22model/crn22ull_1d8_elk_v1d3_1p1_shrink0d855_embedded_usage.scs" section=ffMacro_MOS_MOSCAP
include "/home/soc/zhihc21/7_Amp_complier/FAST_20240508/src/model/spectre_22model/crn22ull_1d8_elk_v1d3_1p1_shrink0d855_embedded_usage.scs" section=pre_simu
// Library name: TSMC22ULL_Std_AMP_LIB
 // Cell name: Yan_AZ_Pin_3
 // View name: schematic
 subckt Yan_AZ_Pin_3 GNDA VDDA VINN VINP VOUT
     M67 (net057 VOUTN VDDA VDDA) pch_ulvt_mac l=MOSFET_0_14_L_BIASCM_PMOS w=MOSFET_0_14_W_BIASCM_PMOS*1 multi=MOSFET_0_14_M_BIASCM_PMOS nf=1
     M3 (net078 VB1 VDDA VDDA) pch_ulvt_mac l=MOSFET_0_14_L_BIASCM_PMOS w=MOSFET_0_14_W_BIASCM_PMOS*1 multi=4*MOSFET_0_14_M_BIASCM_PMOS nf=1
     M13 (VOUT net050 VDDA VDDA) pch_ulvt_mac l=MOSFET_13_1_L_gmf2_PMOS w=MOSFET_13_1_W_gmf2_PMOS*1 multi=MOSFET_13_1_M_gmf2_PMOS nf=1
     M11 (net094 net050 VDDA VDDA) pch_ulvt_mac l=MOSFET_11_1_L_gm2_PMOS w=MOSFET_11_1_W_gm2_PMOS*1 multi=MOSFET_11_1_M_gm2_PMOS nf=1
     M5 (net050 VOUTN VDDA VDDA) pch_ulvt_mac l=MOSFET_0_14_L_BIASCM_PMOS w=MOSFET_0_14_W_BIASCM_PMOS*1 multi=MOSFET_0_14_M_BIASCM_PMOS nf=1
     M4 (VOUTN VOUTN VDDA VDDA) pch_ulvt_mac l=MOSFET_0_14_L_BIASCM_PMOS w=MOSFET_0_14_W_BIASCM_PMOS*1 multi=MOSFET_0_14_M_BIASCM_PMOS nf=1
     M10 (net063 VINP net019 net019) pch_ulvt_mac l=MOSFET_9_2_L_gm1_PMOS w=MOSFET_9_2_W_gm1_PMOS*1 multi=MOSFET_9_2_M_gm1_PMOS nf=1
     M9 (DM_2 VINN net019 net019) pch_ulvt_mac l=MOSFET_9_2_L_gm1_PMOS w=MOSFET_9_2_W_gm1_PMOS*1 multi=MOSFET_9_2_M_gm1_PMOS nf=1
     M2 (net019 VB1 VDDA VDDA) pch_ulvt_mac l=MOSFET_0_14_L_BIASCM_PMOS w=MOSFET_0_14_W_BIASCM_PMOS*1 multi=MOSFET_0_14_M_BIASCM_PMOS*2 nf=1
     M1 (VB4 VB1 VDDA VDDA) pch_ulvt_mac l=MOSFET_0_14_L_BIASCM_PMOS w=MOSFET_0_14_W_BIASCM_PMOS*1 multi=MOSFET_0_14_M_BIASCM_PMOS nf=1
     M0 (VB1 VB1 VDDA VDDA) pch_ulvt_mac l=MOSFET_0_14_L_BIASCM_PMOS w=MOSFET_0_14_W_BIASCM_PMOS*1 multi=MOSFET_0_14_M_BIASCM_PMOS nf=1
     M16 (net077 DM_2 GNDA GNDA) nch_ulvt_mac l=MOSFET_16_4_L_gm5_NMOS w=MOSFET_16_4_W_gm5_NMOS*1 multi=MOSFET_16_4_M_gm5_NMOS nf=1
     M17 (net082 net063 GNDA GNDA) nch_ulvt_mac l=MOSFET_16_4_L_gm5_NMOS w=MOSFET_16_4_W_gm5_NMOS*1 multi=MOSFET_16_4_M_gm5_NMOS nf=1
     M18 (VOUT net057 GNDA GNDA) nch_ulvt_mac l=MOSFET_18_1_L_gm3_NMOS w=MOSFET_18_1_W_gm3_NMOS*1 multi=MOSFET_18_1_M_gm3_NMOS nf=1
     M22 (net094 net051 GNDA GNDA) nch_ulvt_mac l=MOSFET_22_1_L_gmb1_NMOS w=MOSFET_22_1_W_gmb1_NMOS*1 multi=MOSFET_22_1_M_gmb1_NMOS nf=1
     M23 (net057 net094 GNDA GNDA) nch_ulvt_mac l=MOSFET_23_1_L_gmb2_NMOS w=MOSFET_23_1_W_gmb2_NMOS*1 multi=MOSFET_23_1_M_gmb2_NMOS nf=1
     M20 (DM_2 VB4 GNDA GNDA) nch_ulvt_mac l=MOSFET_19_16_L_BIASCM_NMOS w=MOSFET_19_16_W_BIASCM_NMOS*1 multi=MOSFET_19_16_M_BIASCM_NMOS nf=1
     M14 (VOUTN net077 DM_2 GNDA) nch_ulvt_mac l=MOSFET_14_4_L_gm8_NMOS w=MOSFET_14_4_W_gm8_NMOS*1 multi=MOSFET_14_4_M_gm8_NMOS nf=1
     M21 (net063 VB4 GNDA GNDA) nch_ulvt_mac l=MOSFET_19_16_L_BIASCM_NMOS w=MOSFET_19_16_W_BIASCM_NMOS*1 multi=MOSFET_19_16_M_BIASCM_NMOS nf=1
     M15 (net050 net082 net063 GNDA) nch_ulvt_mac l=MOSFET_14_4_L_gm8_NMOS w=MOSFET_14_4_W_gm8_NMOS*1 multi=MOSFET_14_4_M_gm8_NMOS nf=1
     M19 (VB4 VB4 GNDA GNDA) nch_ulvt_mac l=MOSFET_19_16_L_BIASCM_NMOS w=MOSFET_19_16_W_BIASCM_NMOS*1 multi=MOSFET_19_16_M_BIASCM_NMOS nf=1
     I0 (VB1 GNDA) isource dc=CURRENT_1_BIAS type=dc
     C1 (net051 GNDA) capacitor c=CAPACITOR_0
     C0 (net063 VOUT) capacitor c=CAPACITOR_1
     R2 (net094 net051) resistor r=RESISTOR_0
     R1 (net078 net082) resistor r=RESISTOR_2
     R0 (net078 net077) resistor r=RESISTOR_1
 ends Yan_AZ_Pin_3
 // Library name: TSMC22ULL_Std_AMP_LIB
 // Cell name: TB_Yan_AZ_Pin_3
 // View name: schematic
 V8 (VDD_PSRR 0) vsource dc=VDD mag=1 type=dc
 V7 (VIN_P_PSRR 0) vsource dc=VCM mag=0 phase=0 type=dc
 V6 (VIN_P_CMRR_TB net17) vsource dc=0 mag=1 phase=0 type=dc
 V5 (VIN_M_CMRR_TB VOUT_CMRR_TB) vsource dc=0 mag=1 phase=0 type=dc
 V3 (net17 0) vsource dc=VCM mag=0 phase=0 type=dc
 V2 (VINP 0) vsource dc=VCM mag=1 phase=0 type=dc
 V0 (VDD 0) vsource dc=VDD type=dc
 C2 (VOUT_PSRR 0) capacitor c=CLOAD
 C1 (VOUT_CMRR_TB 0) capacitor c=CLOAD
 C0 (VOUT 0) capacitor c=CLOAD
 I34 (0 VDD VIN_M VINP VOUT) Yan_AZ_Pin_3
 I33 (0 VDD_PSRR VIN_M_PSRR VIN_P_PSRR VOUT_PSRR) Yan_AZ_Pin_3
 I32 (0 VDD VIN_M_CMRR_TB VIN_P_CMRR_TB VOUT_CMRR_TB) Yan_AZ_Pin_3
 IPRB2 (VOUT_PSRR VIN_M_PSRR) iprobe
 IPRB0 (VOUT VIN_M) iprobe
simulatorOptions options temp=125
 ac ac start=0.1 stop=10G
 stb stb start=0.01 stop=100G probe=IPRB0 localgnd=0
 dcOp dc
 dc dc param=temp start=-50 stop=150
 noise ( VOUT 0 ) noise start=1 stop=10G iprobe=V2 annotate=status
 pz ( VOUT 0 ) pz iprobe=V2 freq=1 param=VCM start=0 stop=600m
 save VOUT VINP VOUT_CMRR_TB VOUT_PSRR V8:n
saveOptions options save=selected

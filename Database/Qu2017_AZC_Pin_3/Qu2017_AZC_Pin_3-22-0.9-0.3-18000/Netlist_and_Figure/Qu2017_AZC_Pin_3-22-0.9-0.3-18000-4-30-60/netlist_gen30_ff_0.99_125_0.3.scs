 // Design library name: TSMC22ULL_Std_AMP_LIB
 // Design cell name: TB_Qu2017_AZC_Pin_3
 simulator lang=spectre
 global 0
 parameters CURRENT_0_BIAS=3.1u RESISTOR_0=35.0k CAPACITOR_0=0.81p CAPACITOR_1=0.404p CAPACITOR_2=0.31p MOSFET_0_14_L_BIASCM_PMOS=0.75u MOSFET_0_14_M_BIASCM_PMOS=6.0 MOSFET_0_14_W_BIASCM_PMOS=0.96u MOSFET_11_1_L_gm2_PMOS=0.52u MOSFET_11_1_M_gm2_PMOS=5.0 MOSFET_11_1_W_gm2_PMOS=0.959u MOSFET_12_1_L_AZC1_NMOS=0.76u MOSFET_12_1_M_AZC1_NMOS=36.0 MOSFET_12_1_W_AZC1_NMOS=1.0u MOSFET_13_1_L_gmf2_PMOS=0.36u MOSFET_13_1_M_gmf2_PMOS=1.0 MOSFET_13_1_W_gmf2_PMOS=0.918u MOSFET_14_4_L_LOAD1_NMOS=0.488u MOSFET_14_4_M_LOAD1_NMOS=1.0 MOSFET_14_4_W_LOAD1_NMOS=0.91u MOSFET_18_1_L_gm3_NMOS=0.566u MOSFET_18_1_M_gm3_NMOS=6.0 MOSFET_18_1_W_gm3_NMOS=0.566u MOSFET_19_16_L_BIASCM_NMOS=0.85u MOSFET_19_16_M_BIASCM_NMOS=1.0 MOSFET_19_16_W_BIASCM_NMOS=0.93u MOSFET_24_8_L_AZC3_NMOS=0.299u MOSFET_24_8_M_AZC3_NMOS=3.0 MOSFET_24_8_W_AZC3_NMOS=1.0u MOSFET_6_3_L_AZC2_PMOS=0.85u MOSFET_6_3_M_AZC2_PMOS=5.0 MOSFET_6_3_W_AZC2_PMOS=0.934u MOSFET_9_2_L_gm1_PMOS=0.85u MOSFET_9_2_M_gm1_PMOS=18.0 MOSFET_9_2_W_gm1_PMOS=1.0u RESISTOR_1=35.0k RESISTOR_2=350.0k RESISTOR_3=40.0k CLOAD=18000p VCM=0.3 VDD=0.99
 include "/home/soc/zhihc21/7_Amp_complier/FAST_20240508/src/model/spectre_22model/crn22ull_1d8_elk_v1d3_1p1_shrink0d855_embedded_usage.scs" section=ffMacro_MOS_MOSCAP
include "/home/soc/zhihc21/7_Amp_complier/FAST_20240508/src/model/spectre_22model/crn22ull_1d8_elk_v1d3_1p1_shrink0d855_embedded_usage.scs" section=pre_simu
// Library name: TSMC22ULL_Std_AMP_LIB
 // Cell name: Qu2017_AZC_Pin_3
 // View name: schematic
 subckt Qu2017_AZC_Pin_3 GNDA VDDA VINN VINP VOUT
     M7 (net057 net055 VDDA VDDA) pch_ulvt_mac l=MOSFET_6_3_L_AZC2_PMOS w=MOSFET_6_3_W_AZC2_PMOS*1 multi=MOSFET_6_3_M_AZC2_PMOS*2 nf=1
     M6 (net055 net055 VDDA VDDA) pch_ulvt_mac l=MOSFET_6_3_L_AZC2_PMOS w=MOSFET_6_3_W_AZC2_PMOS*1 multi=MOSFET_6_3_M_AZC2_PMOS nf=1
     M3 (net078 VB1 VDDA VDDA) pch_ulvt_mac l=MOSFET_0_14_L_BIASCM_PMOS w=MOSFET_0_14_W_BIASCM_PMOS*1 multi=6*MOSFET_0_14_M_BIASCM_PMOS nf=1
     M13 (VOUT net050 VDDA VDDA) pch_ulvt_mac l=MOSFET_13_1_L_gmf2_PMOS w=MOSFET_13_1_W_gmf2_PMOS*1 multi=MOSFET_13_1_M_gmf2_PMOS nf=1
     M8 (net049 VB1_1 VDDA VDDA) pch_ulvt_mac l=MOSFET_0_14_L_BIASCM_PMOS w=MOSFET_0_14_W_BIASCM_PMOS*1 multi=MOSFET_0_14_M_BIASCM_PMOS*2 nf=1
     M11 (net094 net050 VDDA VDDA) pch_ulvt_mac l=MOSFET_11_1_L_gm2_PMOS w=MOSFET_11_1_W_gm2_PMOS*1 multi=MOSFET_11_1_M_gm2_PMOS nf=1
     M67 (VB1_1 VB1_1 VDDA VDDA) pch_ulvt_mac l=MOSFET_0_14_L_BIASCM_PMOS w=MOSFET_0_14_W_BIASCM_PMOS*1 multi=MOSFET_0_14_M_BIASCM_PMOS*2 nf=1
     M5 (net050 VOUTN VDDA VDDA) pch_ulvt_mac l=MOSFET_0_14_L_BIASCM_PMOS w=MOSFET_0_14_W_BIASCM_PMOS*1 multi=MOSFET_0_14_M_BIASCM_PMOS nf=1
     M4 (VOUTN VOUTN VDDA VDDA) pch_ulvt_mac l=MOSFET_0_14_L_BIASCM_PMOS w=MOSFET_0_14_W_BIASCM_PMOS*1 multi=MOSFET_0_14_M_BIASCM_PMOS nf=1
     M10 (net063 VINP net019 net019) pch_ulvt_mac l=MOSFET_9_2_L_gm1_PMOS w=MOSFET_9_2_W_gm1_PMOS*1 multi=MOSFET_9_2_M_gm1_PMOS nf=1
     M9 (DM_2 VINN net019 net019) pch_ulvt_mac l=MOSFET_9_2_L_gm1_PMOS w=MOSFET_9_2_W_gm1_PMOS*1 multi=MOSFET_9_2_M_gm1_PMOS nf=1
     M2 (net019 VB1 VDDA VDDA) pch_ulvt_mac l=MOSFET_0_14_L_BIASCM_PMOS w=MOSFET_0_14_W_BIASCM_PMOS*1 multi=MOSFET_0_14_M_BIASCM_PMOS*2 nf=1
     M1 (VB4 VB1 VDDA VDDA) pch_ulvt_mac l=MOSFET_0_14_L_BIASCM_PMOS w=MOSFET_0_14_W_BIASCM_PMOS*1 multi=MOSFET_0_14_M_BIASCM_PMOS nf=1
     M0 (VB1 VB1 VDDA VDDA) pch_ulvt_mac l=MOSFET_0_14_L_BIASCM_PMOS w=MOSFET_0_14_W_BIASCM_PMOS*1 multi=MOSFET_0_14_M_BIASCM_PMOS nf=1
     M24 (net049 net057 GNDA GNDA) nch_ulvt_mac l=MOSFET_24_8_L_AZC3_NMOS w=MOSFET_24_8_W_AZC3_NMOS*1 multi=MOSFET_24_8_M_AZC3_NMOS nf=1
     M12 (net055 net094 GNDA GNDA) nch_ulvt_mac l=MOSFET_12_1_L_AZC1_NMOS w=MOSFET_12_1_W_AZC1_NMOS*1 multi=MOSFET_12_1_M_AZC1_NMOS nf=1
     M16 (net077 DM_2 GNDA GNDA) nch_ulvt_mac l=MOSFET_14_4_L_LOAD1_NMOS w=MOSFET_14_4_W_LOAD1_NMOS*1 multi=MOSFET_14_4_M_LOAD1_NMOS nf=1
     M17 (net082 net063 GNDA GNDA) nch_ulvt_mac l=MOSFET_14_4_L_LOAD1_NMOS w=MOSFET_14_4_W_LOAD1_NMOS*1 multi=MOSFET_14_4_M_LOAD1_NMOS nf=1
     M18 (VOUT net049 GNDA GNDA) nch_ulvt_mac l=MOSFET_18_1_L_gm3_NMOS w=MOSFET_18_1_W_gm3_NMOS*1 multi=MOSFET_18_1_M_gm3_NMOS nf=1
     M22 (net094 net051 GNDA GNDA) nch_ulvt_mac l=MOSFET_24_8_L_AZC3_NMOS w=MOSFET_24_8_W_AZC3_NMOS*1 multi=MOSFET_24_8_M_AZC3_NMOS*4 nf=1
     M23 (net057 net043 GNDA GNDA) nch_ulvt_mac l=MOSFET_24_8_L_AZC3_NMOS w=MOSFET_24_8_W_AZC3_NMOS*1 multi=MOSFET_24_8_M_AZC3_NMOS*3 nf=1
     M20 (DM_2 VB4 GNDA GNDA) nch_ulvt_mac l=MOSFET_19_16_L_BIASCM_NMOS w=MOSFET_19_16_W_BIASCM_NMOS*7 multi=MOSFET_19_16_M_BIASCM_NMOS nf=7
     M14 (VOUTN net077 DM_2 GNDA) nch_ulvt_mac l=MOSFET_14_4_L_LOAD1_NMOS w=MOSFET_14_4_W_LOAD1_NMOS*1 multi=MOSFET_14_4_M_LOAD1_NMOS nf=1
     M21 (net063 VB4 GNDA GNDA) nch_ulvt_mac l=MOSFET_19_16_L_BIASCM_NMOS w=MOSFET_19_16_W_BIASCM_NMOS*7 multi=MOSFET_19_16_M_BIASCM_NMOS nf=7
     M15 (net050 net082 net063 GNDA) nch_ulvt_mac l=MOSFET_14_4_L_LOAD1_NMOS w=MOSFET_14_4_W_LOAD1_NMOS*1 multi=MOSFET_14_4_M_LOAD1_NMOS nf=1
     M19 (VB4 VB4 GNDA GNDA) nch_ulvt_mac l=MOSFET_19_16_L_BIASCM_NMOS w=MOSFET_19_16_W_BIASCM_NMOS*2 multi=MOSFET_19_16_M_BIASCM_NMOS nf=2
     M69 (VB1_1 VB4 GNDA GNDA) nch_ulvt_mac l=MOSFET_19_16_L_BIASCM_NMOS w=MOSFET_19_16_W_BIASCM_NMOS*2 multi=MOSFET_19_16_M_BIASCM_NMOS nf=2
     I0 (VB1 GNDA) isource dc=CURRENT_0_BIAS type=dc
     C2 (net043 GNDA) capacitor c=CAPACITOR_2
     C1 (net051 GNDA) capacitor c=CAPACITOR_1
     C0 (net063 VOUT) capacitor c=CAPACITOR_0
     R3 (net057 net043) resistor r=RESISTOR_3
     R2 (net057 net051) resistor r=RESISTOR_2
     R1 (net078 net082) resistor r=RESISTOR_1
     R0 (net078 net077) resistor r=RESISTOR_0
 ends Qu2017_AZC_Pin_3
 // Library name: TSMC22ULL_Std_AMP_LIB
 // Cell name: TB_Qu2017_AZC_Pin_3
 // View name: schematic
 V8 (VDD_PSRR 0) vsource dc=VDD mag=1 type=dc
 V7 (VIN_P_PSRR 0) vsource dc=VCM mag=0 phase=0 type=dc
 V6 (VIN_P_CMRR_TB net17) vsource dc=0 mag=1 phase=0 type=dc
 V5 (VIN_M_CMRR_TB VOUT_CMRR_TB) vsource dc=0 mag=1 phase=0 type=dc
 V3 (net17 0) vsource dc=VCM mag=0 phase=0 type=dc
 V2 (VINP 0) vsource dc=VCM mag=1 phase=0 type=dc
 V0 (VDD 0) vsource dc=VDD type=dc
 C2 (VOUT_PSRR 0) capacitor c=CLOAD
 C1 (VOUT_CMRR_TB 0) capacitor c=CLOAD
 C0 (VOUT 0) capacitor c=CLOAD
 I30 (0 VDD_PSRR VIN_M_PSRR VIN_P_PSRR VOUT_PSRR) Qu2017_AZC_Pin_3
 I31 (0 VDD VIN_M VINP VOUT) Qu2017_AZC_Pin_3
 I29 (0 VDD VIN_M_CMRR_TB VIN_P_CMRR_TB VOUT_CMRR_TB) Qu2017_AZC_Pin_3
 IPRB2 (VOUT_PSRR VIN_M_PSRR) iprobe
 IPRB0 (VOUT VIN_M) iprobe
simulatorOptions options temp=125
 ac ac start=0.1 stop=10G
 stb stb start=0.01 stop=100G dec=100 probe=IPRB0 localgnd=0
 dcOp dc
 dc dc param=temp start=-50 stop=150
 noise ( VOUT 0 ) noise start=1 stop=10G iprobe=V2 annotate=status
 pz ( VOUT 0 ) pz iprobe=V2 freq=1 param=VCM start=0 stop=0.6
 save VOUT VINP VOUT_CMRR_TB VOUT_PSRR V8:n
saveOptions options save=selected

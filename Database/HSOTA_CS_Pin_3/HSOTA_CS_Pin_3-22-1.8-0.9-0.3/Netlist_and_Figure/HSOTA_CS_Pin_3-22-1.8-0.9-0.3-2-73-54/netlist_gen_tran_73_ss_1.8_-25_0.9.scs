 // Design library name: 2025_5_DCDC_TO
 // Design cell name: TB_TRAN_HSOTA_CS_Pin_3
 simulator lang=spectre
 global 0
 parameters MOSFET_6_2_M_LOAD3_PMOS=1.0 MOSFET_6_2_W_LOAD3_PMOS=0.3u MOSFET_0_2_M_LOAD2_NMOS=46.0 MOSFET_0_2_W_LOAD2_NMOS=0.3u MOSFET_10_2_L_gm1_PMOS=0.656u MOSFET_10_2_M_gm1_PMOS=1.0 MOSFET_10_2_W_gm1_PMOS=0.972u MOSFET_13_2_M_gm2_PMOS=1.0 MOSFET_13_2_W_gm2_PMOS=1.55u MOSFET_1_2_M_gm3_NMOS=21.0 MOSFET_1_2_W_gm3_NMOS=0.373u MOSFET_28_10_L_BIASCM_NMOS=0.536u MOSFET_28_10_M_BIASCM_NMOS=1.0 MOSFET_28_10_W_BIASCM_NMOS=2.0u MOSFET_33_10_L_BIASCM_PMOS=0.831u MOSFET_33_10_M_BIASCM_PMOS=14.0 MOSFET_33_10_W_BIASCM_PMOS=1.94u CURRENT_0_BIAS=47.0u CLOAD=0.3p VCM=0.9 VDD=1.8
 include "/home/soc/zhihc21/7_Amp_complier/FAST_20240508/src/model/spectre_22model/crn22ull_1d8_elk_v1d3_1p1_shrink0d855_embedded_usage.scs" section=ssMacro_MOS_MOSCAP
include "/home/soc/zhihc21/7_Amp_complier/FAST_20240508/src/model/spectre_22model/crn22ull_1d8_elk_v1d3_1p1_shrink0d855_embedded_usage.scs" section=pre_simu
// Library name: 2025_5_DCDC_TO
 // Cell name: HSOTA_CS_Pin_3
 // View name: schematic
 subckt HSOTA_CS_Pin_3 GNDA VDDA VINN VINP VOUT
     R1 (net5 net13) resistor r=60K
     R0 (net13 net38) resistor r=60K
     R2 (net3 GNDA) resistor r=30K
     R3 (GNDA net19) resistor r=30K
     M30 (VBN1 VBN1 GNDA GNDA) nch_18_mac l=MOSFET_28_10_L_BIASCM_NMOS w=MOSFET_28_10_W_BIASCM_NMOS*1 multi=MOSFET_28_10_M_BIASCM_NMOS nf=1
     M31 (VBP2 VBN1 net2 GNDA) nch_18_mac l=MOSFET_28_10_L_BIASCM_NMOS w=MOSFET_28_10_W_BIASCM_NMOS*1 multi=MOSFET_28_10_M_BIASCM_NMOS*4 nf=1
     M28 (VBN2 VBN1 net46 GNDA) nch_18_mac l=MOSFET_28_10_L_BIASCM_NMOS w=MOSFET_28_10_W_BIASCM_NMOS*1 multi=MOSFET_28_10_M_BIASCM_NMOS*4 nf=1
     M29 (net46 VBN2 GNDA GNDA) nch_18_mac l=MOSFET_28_10_L_BIASCM_NMOS w=MOSFET_28_10_W_BIASCM_NMOS*1 multi=MOSFET_28_10_M_BIASCM_NMOS*4 nf=1
     M32 (net2 VBN2 GNDA GNDA) nch_18_mac l=MOSFET_28_10_L_BIASCM_NMOS w=MOSFET_28_10_W_BIASCM_NMOS*1 multi=MOSFET_28_10_M_BIASCM_NMOS*4 nf=1
     M19 (VOUT VBN1 net43 GNDA) nch_18_mac l=MOSFET_28_10_L_BIASCM_NMOS w=MOSFET_28_10_W_BIASCM_NMOS*1 multi=MOSFET_28_10_M_BIASCM_NMOS*8 nf=1
     M15 (net39 VBN1 net41 GNDA) nch_18_mac l=MOSFET_28_10_L_BIASCM_NMOS w=MOSFET_28_10_W_BIASCM_NMOS*1 multi=MOSFET_28_10_M_BIASCM_NMOS*8 nf=1
     I1 (VBP1 GNDA) isource dc=CURRENT_0_BIAS type=dc
     M35 (net1 VBP1 VDDA VDDA) pch_18_mac l=MOSFET_33_10_L_BIASCM_PMOS w=MOSFET_33_10_W_BIASCM_PMOS*1 multi=MOSFET_33_10_M_BIASCM_PMOS*4 nf=1
     M34 (net45 VBP1 VDDA VDDA) pch_18_mac l=MOSFET_33_10_L_BIASCM_PMOS w=MOSFET_33_10_W_BIASCM_PMOS*1 multi=MOSFET_33_10_M_BIASCM_PMOS*4 nf=1
     M33 (net42 VBP1 VDDA VDDA) pch_18_mac l=MOSFET_33_10_L_BIASCM_PMOS w=MOSFET_33_10_W_BIASCM_PMOS*1 multi=MOSFET_33_10_M_BIASCM_PMOS*4 nf=1
     M27 (VBP1 VBP2 net42 VDDA) pch_18_mac l=MOSFET_33_10_L_BIASCM_PMOS w=MOSFET_33_10_W_BIASCM_PMOS*1 multi=MOSFET_33_10_M_BIASCM_PMOS*4 nf=1
     M26 (VBN1 VBP2 net1 VDDA) pch_18_mac l=MOSFET_33_10_L_BIASCM_PMOS w=MOSFET_33_10_W_BIASCM_PMOS*1 multi=MOSFET_33_10_M_BIASCM_PMOS*4 nf=1
     M25 (VBP2 VBP2 VDDA VDDA) pch_18_mac l=MOSFET_33_10_L_BIASCM_PMOS w=MOSFET_33_10_W_BIASCM_PMOS*1 multi=MOSFET_33_10_M_BIASCM_PMOS*1 nf=1
     M24 (VBN2 VBP2 net45 VDDA) pch_18_mac l=MOSFET_33_10_L_BIASCM_PMOS w=MOSFET_33_10_W_BIASCM_PMOS*1 multi=MOSFET_33_10_M_BIASCM_PMOS*4 nf=1
     M21 (VOUT VBP2 net44 VDDA) pch_18_mac l=MOSFET_33_10_L_BIASCM_PMOS w=MOSFET_33_10_W_BIASCM_PMOS*1 multi=MOSFET_33_10_M_BIASCM_PMOS*8 nf=1
     M17 (net39 VBP2 net40 VDDA) pch_18_mac l=MOSFET_33_10_L_BIASCM_PMOS w=MOSFET_33_10_W_BIASCM_PMOS*1 multi=MOSFET_33_10_M_BIASCM_PMOS*8 nf=1
     M9 (VDDA VBP1 VDDA VDDA) pch_18_mac l=150n w=320n multi=1 nf=1
     M36 (VDDA VBP2 VDDA VDDA) pch_18_mac l=150n w=320n multi=1 nf=1
     M12 (net6 VBP1 VDDA VDDA) pch_18_mac l=MOSFET_33_10_L_BIASCM_PMOS w=MOSFET_33_10_W_BIASCM_PMOS*1 multi=MOSFET_33_10_M_BIASCM_PMOS*32 nf=1
     M7 (net4 VBP1 VDDA VDDA) pch_18_mac l=MOSFET_33_10_L_BIASCM_PMOS w=MOSFET_33_10_W_BIASCM_PMOS*1 multi=MOSFET_33_10_M_BIASCM_PMOS*32 nf=1
     M11 (net19 VINP net4 net4) pch_18_mac l=MOSFET_10_2_L_gm1_PMOS w=MOSFET_10_2_W_gm1_PMOS*1 multi=MOSFET_10_2_M_gm1_PMOS nf=1
     M10 (net3 VINN net4 net4) pch_18_mac l=MOSFET_10_2_L_gm1_PMOS w=MOSFET_10_2_W_gm1_PMOS*1 multi=MOSFET_10_2_M_gm1_PMOS nf=1
     M4 (net44 net39 VDDA VDDA) pch_ulvt_mac l=30n w=MOSFET_6_2_W_LOAD3_PMOS*1 multi=MOSFET_6_2_M_LOAD3_PMOS nf=1
     M6 (net40 net39 VDDA VDDA) pch_ulvt_mac l=30n w=MOSFET_6_2_W_LOAD3_PMOS*1 multi=MOSFET_6_2_M_LOAD3_PMOS nf=1
     M13 (net5 net3 net6 net6) pch_ulvt_mac l=30n w=MOSFET_13_2_W_gm2_PMOS*1 multi=MOSFET_13_2_M_gm2_PMOS nf=1
     M14 (net38 net19 net6 net6) pch_ulvt_mac l=30n w=MOSFET_13_2_W_gm2_PMOS*1 multi=MOSFET_13_2_M_gm2_PMOS nf=1
     M2 (net41 net38 GNDA GNDA) nch_ulvt_mac l=30n w=MOSFET_1_2_W_gm3_NMOS*1 multi=MOSFET_1_2_M_gm3_NMOS nf=1
     M3 (net5 net13 GNDA GNDA) nch_ulvt_mac l=30n w=MOSFET_0_2_W_LOAD2_NMOS*1 multi=MOSFET_0_2_M_LOAD2_NMOS nf=1
     M1 (net43 net5 GNDA GNDA) nch_ulvt_mac l=30n w=MOSFET_1_2_W_gm3_NMOS*1 multi=MOSFET_1_2_M_gm3_NMOS nf=1
     M0 (net38 net13 GNDA GNDA) nch_ulvt_mac l=30n w=MOSFET_0_2_W_LOAD2_NMOS*1 multi=MOSFET_0_2_M_LOAD2_NMOS nf=1
 ends HSOTA_CS_Pin_3
 // Library name: 2025_5_DCDC_TO
 // Cell name: TB_TRAN_HSOTA_CS_Pin_3
 // View name: schematic
 V0 (VDD 0) vsource dc=VDD type=dc
 C0 (SR_VOUT 0) capacitor c=CLOAD
 I20 (0 VDD SR_VOUT SR_VINP SR_VOUT) HSOTA_CS_Pin_3
 V1 (SR_VINP 0) vsource dc=0 type=pulse delay=1u edgetype=linear val0=0.5 val1=1.2 period=1 rise=1p fall=1p width=9.19e-06
simulatorOptions options temp=-25
 tran tran stop=1.94e-05
 save SR_VOUT SR_VINP
saveOptions options save=selected

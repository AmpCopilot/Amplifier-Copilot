 // Design library name: 2025_5_DCDC_TO
 // Design cell name: TB_HSOTA_CS_Pin_3
 simulator lang=spectre
 global 0
 parameters _EXPR_2=PULSE_WIDTH*10+1u MOSFET_6_2_M_LOAD3_PMOS=1.0 MOSFET_6_2_W_LOAD3_PMOS=0.3u MOSFET_0_2_M_LOAD2_NMOS=46.0 MOSFET_0_2_W_LOAD2_NMOS=0.3u MOSFET_10_2_L_gm1_PMOS=0.632u MOSFET_10_2_M_gm1_PMOS=1.0 MOSFET_10_2_W_gm1_PMOS=0.995u MOSFET_13_2_M_gm2_PMOS=1.0 MOSFET_13_2_W_gm2_PMOS=1.74u MOSFET_1_2_M_gm3_NMOS=20.0 MOSFET_1_2_W_gm3_NMOS=0.302u MOSFET_28_10_L_BIASCM_NMOS=0.795u MOSFET_28_10_M_BIASCM_NMOS=1.0 MOSFET_28_10_W_BIASCM_NMOS=2.0u MOSFET_33_10_L_BIASCM_PMOS=0.911u MOSFET_33_10_M_BIASCM_PMOS=16.0 MOSFET_33_10_W_BIASCM_PMOS=1.91u CURRENT_0_BIAS=45.0u CLOAD=0.3p VCM=0.9 VDD=1.8
 include "/home/soc/zhihc21/7_Amp_complier/FAST_20240508/src/model/spectre_22model/crn22ull_1d8_elk_v1d3_1p1_shrink0d855_embedded_usage.scs" section=ssMacro_MOS_MOSCAP
include "/home/soc/zhihc21/7_Amp_complier/FAST_20240508/src/model/spectre_22model/crn22ull_1d8_elk_v1d3_1p1_shrink0d855_embedded_usage.scs" section=pre_simu
// Library name: 2025_5_DCDC_TO
 // Cell name: HSOTA_CS_Pin_3
 // View name: schematic
 subckt HSOTA_CS_Pin_3 GNDA VDDA VINN VINP VOUT
     R1 (net5 net13) resistor r=60K
     R0 (net13 net38) resistor r=60K
     R2 (net3 GNDA) resistor r=30K
     R3 (GNDA net19) resistor r=30K
     M30 (VBN1 VBN1 GNDA GNDA) nch_18_mac l=MOSFET_28_10_L_BIASCM_NMOS w=MOSFET_28_10_W_BIASCM_NMOS*1 multi=MOSFET_28_10_M_BIASCM_NMOS nf=1
     M31 (VBP2 VBN1 net2 GNDA) nch_18_mac l=MOSFET_28_10_L_BIASCM_NMOS w=MOSFET_28_10_W_BIASCM_NMOS*1 multi=MOSFET_28_10_M_BIASCM_NMOS*4 nf=1
     M28 (VBN2 VBN1 net46 GNDA) nch_18_mac l=MOSFET_28_10_L_BIASCM_NMOS w=MOSFET_28_10_W_BIASCM_NMOS*1 multi=MOSFET_28_10_M_BIASCM_NMOS*4 nf=1
     M29 (net46 VBN2 GNDA GNDA) nch_18_mac l=MOSFET_28_10_L_BIASCM_NMOS w=MOSFET_28_10_W_BIASCM_NMOS*1 multi=MOSFET_28_10_M_BIASCM_NMOS*4 nf=1
     M32 (net2 VBN2 GNDA GNDA) nch_18_mac l=MOSFET_28_10_L_BIASCM_NMOS w=MOSFET_28_10_W_BIASCM_NMOS*1 multi=MOSFET_28_10_M_BIASCM_NMOS*4 nf=1
     M19 (VOUT VBN1 net43 GNDA) nch_18_mac l=MOSFET_28_10_L_BIASCM_NMOS w=MOSFET_28_10_W_BIASCM_NMOS*1 multi=MOSFET_28_10_M_BIASCM_NMOS*8 nf=1
     M15 (net39 VBN1 net41 GNDA) nch_18_mac l=MOSFET_28_10_L_BIASCM_NMOS w=MOSFET_28_10_W_BIASCM_NMOS*1 multi=MOSFET_28_10_M_BIASCM_NMOS*8 nf=1
     I1 (VBP1 GNDA) isource dc=CURRENT_0_BIAS type=dc
     M35 (net1 VBP1 VDDA VDDA) pch_18_mac l=MOSFET_33_10_L_BIASCM_PMOS w=MOSFET_33_10_W_BIASCM_PMOS*1 multi=MOSFET_33_10_M_BIASCM_PMOS*4 nf=1
     M34 (net45 VBP1 VDDA VDDA) pch_18_mac l=MOSFET_33_10_L_BIASCM_PMOS w=MOSFET_33_10_W_BIASCM_PMOS*1 multi=MOSFET_33_10_M_BIASCM_PMOS*4 nf=1
     M33 (net42 VBP1 VDDA VDDA) pch_18_mac l=MOSFET_33_10_L_BIASCM_PMOS w=MOSFET_33_10_W_BIASCM_PMOS*1 multi=MOSFET_33_10_M_BIASCM_PMOS*4 nf=1
     M27 (VBP1 VBP2 net42 VDDA) pch_18_mac l=MOSFET_33_10_L_BIASCM_PMOS w=MOSFET_33_10_W_BIASCM_PMOS*1 multi=MOSFET_33_10_M_BIASCM_PMOS*4 nf=1
     M26 (VBN1 VBP2 net1 VDDA) pch_18_mac l=MOSFET_33_10_L_BIASCM_PMOS w=MOSFET_33_10_W_BIASCM_PMOS*1 multi=MOSFET_33_10_M_BIASCM_PMOS*4 nf=1
     M25 (VBP2 VBP2 VDDA VDDA) pch_18_mac l=MOSFET_33_10_L_BIASCM_PMOS w=MOSFET_33_10_W_BIASCM_PMOS*1 multi=MOSFET_33_10_M_BIASCM_PMOS*1 nf=1
     M24 (VBN2 VBP2 net45 VDDA) pch_18_mac l=MOSFET_33_10_L_BIASCM_PMOS w=MOSFET_33_10_W_BIASCM_PMOS*1 multi=MOSFET_33_10_M_BIASCM_PMOS*4 nf=1
     M21 (VOUT VBP2 net44 VDDA) pch_18_mac l=MOSFET_33_10_L_BIASCM_PMOS w=MOSFET_33_10_W_BIASCM_PMOS*1 multi=MOSFET_33_10_M_BIASCM_PMOS*8 nf=1
     M17 (net39 VBP2 net40 VDDA) pch_18_mac l=MOSFET_33_10_L_BIASCM_PMOS w=MOSFET_33_10_W_BIASCM_PMOS*1 multi=MOSFET_33_10_M_BIASCM_PMOS*8 nf=1
     M9 (VDDA VBP1 VDDA VDDA) pch_18_mac l=150n w=320n multi=1 nf=1
     M36 (VDDA VBP2 VDDA VDDA) pch_18_mac l=150n w=320n multi=1 nf=1
     M12 (net6 VBP1 VDDA VDDA) pch_18_mac l=MOSFET_33_10_L_BIASCM_PMOS w=MOSFET_33_10_W_BIASCM_PMOS*1 multi=MOSFET_33_10_M_BIASCM_PMOS*32 nf=1
     M7 (net4 VBP1 VDDA VDDA) pch_18_mac l=MOSFET_33_10_L_BIASCM_PMOS w=MOSFET_33_10_W_BIASCM_PMOS*1 multi=MOSFET_33_10_M_BIASCM_PMOS*32 nf=1
     M11 (net19 VINP net4 net4) pch_18_mac l=MOSFET_10_2_L_gm1_PMOS w=MOSFET_10_2_W_gm1_PMOS*1 multi=MOSFET_10_2_M_gm1_PMOS nf=1
     M10 (net3 VINN net4 net4) pch_18_mac l=MOSFET_10_2_L_gm1_PMOS w=MOSFET_10_2_W_gm1_PMOS*1 multi=MOSFET_10_2_M_gm1_PMOS nf=1
     M4 (net44 net39 VDDA VDDA) pch_ulvt_mac l=30n w=MOSFET_6_2_W_LOAD3_PMOS*1 multi=MOSFET_6_2_M_LOAD3_PMOS nf=1
     M6 (net40 net39 VDDA VDDA) pch_ulvt_mac l=30n w=MOSFET_6_2_W_LOAD3_PMOS*1 multi=MOSFET_6_2_M_LOAD3_PMOS nf=1
     M13 (net5 net3 net6 net6) pch_ulvt_mac l=30n w=MOSFET_13_2_W_gm2_PMOS*1 multi=MOSFET_13_2_M_gm2_PMOS nf=1
     M14 (net38 net19 net6 net6) pch_ulvt_mac l=30n w=MOSFET_13_2_W_gm2_PMOS*1 multi=MOSFET_13_2_M_gm2_PMOS nf=1
     M2 (net41 net38 GNDA GNDA) nch_ulvt_mac l=30n w=MOSFET_1_2_W_gm3_NMOS*1 multi=MOSFET_1_2_M_gm3_NMOS nf=1
     M3 (net5 net13 GNDA GNDA) nch_ulvt_mac l=30n w=MOSFET_0_2_W_LOAD2_NMOS*1 multi=MOSFET_0_2_M_LOAD2_NMOS nf=1
     M1 (net43 net5 GNDA GNDA) nch_ulvt_mac l=30n w=MOSFET_1_2_W_gm3_NMOS*1 multi=MOSFET_1_2_M_gm3_NMOS nf=1
     M0 (net38 net13 GNDA GNDA) nch_ulvt_mac l=30n w=MOSFET_0_2_W_LOAD2_NMOS*1 multi=MOSFET_0_2_M_LOAD2_NMOS nf=1
 ends HSOTA_CS_Pin_3
 // Library name: 2025_5_DCDC_TO
 // Cell name: TB_HSOTA_CS_Pin_3
 // View name: schematic
 V8 (VDD_PSRR 0) vsource dc=VDD mag=1 type=dc
 V7 (VIN_P_PSRR 0) vsource dc=VCM mag=0 phase=0 type=dc
 V6 (VIN_P_CMRR_TB net17) vsource dc=0 mag=1 phase=0 type=dc
 V5 (VIN_M_CMRR_TB VOUT_CMRR_TB) vsource dc=0 mag=1 phase=0 type=dc
 V3 (net17 0) vsource dc=VCM mag=0 phase=0 type=dc
 V2 (VINP 0) vsource dc=VCM mag=1 phase=0 type=dc
 V0 (VDD 0) vsource dc=VDD type=dc
 C2 (VOUT_PSRR 0) capacitor c=CLOAD
 C1 (VOUT_CMRR_TB 0) capacitor c=CLOAD
 C0 (VOUT 0) capacitor c=CLOAD
 I38 (0 VDD VIN_M VINP VOUT) HSOTA_CS_Pin_3
 I37 (0 VDD_PSRR VIN_M_PSRR VIN_P_PSRR VOUT_PSRR) HSOTA_CS_Pin_3
 I36 (0 VDD VIN_M_CMRR_TB VIN_P_CMRR_TB VOUT_CMRR_TB) HSOTA_CS_Pin_3
 IPRB2 (VOUT_PSRR VIN_M_PSRR) iprobe
 IPRB0 (VOUT VIN_M) iprobe
simulatorOptions options temp=-25
 ac ac start=0.1 stop=10G
 stb stb start=0.01 stop=100G probe=IPRB0 localgnd=0
 dcOp dc
 dc dc param=temp start=-50 stop=150
 noise ( VOUT 0 ) noise start=1 stop=10G iprobe=V2 annotate=status
 pz ( VOUT 0 ) pz iprobe=V2 freq=1 param=VCM start=0 stop=600m
 save VOUT VINP VOUT_CMRR_TB VOUT_PSRR V8:n
saveOptions options save=selected

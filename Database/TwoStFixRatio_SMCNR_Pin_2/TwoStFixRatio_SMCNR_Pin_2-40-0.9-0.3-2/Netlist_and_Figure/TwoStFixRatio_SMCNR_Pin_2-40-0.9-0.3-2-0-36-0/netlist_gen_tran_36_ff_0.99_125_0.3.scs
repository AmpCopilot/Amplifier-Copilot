 // Design library name: TSMC22ULL_Std_AMP_LIB
 // Design cell name: TB_TRANTwoStFixIRatio_SMCNR_Pin_2
 simulator lang=spectre
 global 0
 parameters MOSFET_5_2_L_LOAD1_NMOS=0.5692962u MOSFET_5_2_M_LOAD1_NMOS=30.0 MOSFET_5_2_W_LOAD1_NMOS=1.332345u MOSFET_0_1_L_BIASCM0_PMOS=1.196149u MOSFET_0_1_M_BIASCM0_PMOS=30.0 MOSFET_0_1_W_BIASCM0_PMOS=2.879828u MOSFET_3_2_L_gm1_PMOS=0.2988094u MOSFET_3_2_M_gm1_PMOS=8.0 MOSFET_3_2_W_gm1_PMOS=4.741266u MOSFET_7_1_L_gm2_NMOS=0.05134339u MOSFET_7_1_M_gm2_NMOS=14.0 MOSFET_7_1_W_gm2_NMOS=1.760048u CAPACITOR_0=0.3428319p RESISTOR_0=0.4973488k CURRENT_0_BIAS=68.41609u CLOAD=2p VCM=0.3 VDD=0.99
 include "/home/soc/zhihc21/7_Amp_complier/FAST_20240508/src/model/Spectre_40/crn40ulp_esf3_2d5_v1d2_2p1_shrink0d9_embedded_usage.scs" section=ffmacro_mos_moscap
include "/home/soc/zhihc21/7_Amp_complier/FAST_20240508/src/model/Spectre_40/crn40ulp_esf3_2d5_v1d2_2p1_shrink0d9_embedded_usage.scs" section=pre_simu
// Library name: TSMC22ULL_Std_AMP_LIB
 // Cell name: TwoStFixIRatio_SMCNR_Pin_2
 // View name: schematic
 subckt TwoStFixIRatio_SMCNR_Pin_2 GNDA VDDA VINN VINP VOUT
     M0 (net011 net011 VDDA VDDA) pch_elvt_mac l=MOSFET_0_1_L_BIASCM0_PMOS w=MOSFET_0_1_W_BIASCM0_PMOS*1 multi=MOSFET_0_1_M_BIASCM0_PMOS nf=1
     M2 (VOUT net011 VDDA VDDA) pch_elvt_mac l=MOSFET_0_1_L_BIASCM0_PMOS w=MOSFET_0_1_W_BIASCM0_PMOS*1 multi=MOSFET_0_1_M_BIASCM0_PMOS*8 nf=1
     M1 (net73 net011 VDDA VDDA) pch_elvt_mac l=MOSFET_0_1_L_BIASCM0_PMOS w=MOSFET_0_1_W_BIASCM0_PMOS*1 multi=MOSFET_0_1_M_BIASCM0_PMOS*2 nf=1
     M3 (OUTP VINN net73 net73) pch_elvt_mac l=MOSFET_3_2_L_gm1_PMOS w=MOSFET_3_2_W_gm1_PMOS*1 multi=MOSFET_3_2_M_gm1_PMOS nf=1
     M4 (OUTN VINP net73 net73) pch_elvt_mac l=MOSFET_3_2_L_gm1_PMOS w=MOSFET_3_2_W_gm1_PMOS*1 multi=MOSFET_3_2_M_gm1_PMOS nf=1
     R0 (VOUT net72) resistor r=RESISTOR_0
     C0 (OUTN net72) capacitor c=CAPACITOR_0
     I6 (net011 GNDA) isource dc=CURRENT_0_BIAS type=dc
     M6 (OUTN OUTP GNDA GNDA) nch_elvt_mac l=MOSFET_5_2_L_LOAD1_NMOS w=MOSFET_5_2_W_LOAD1_NMOS*1 multi=MOSFET_5_2_M_LOAD1_NMOS nf=1
     M5 (OUTP OUTP GNDA GNDA) nch_elvt_mac l=MOSFET_5_2_L_LOAD1_NMOS w=MOSFET_5_2_W_LOAD1_NMOS*1 multi=MOSFET_5_2_M_LOAD1_NMOS nf=1
     M7 (VOUT OUTN GNDA GNDA) nch_elvt_mac l=MOSFET_7_1_L_gm2_NMOS w=MOSFET_7_1_W_gm2_NMOS*1 multi=MOSFET_7_1_M_gm2_NMOS nf=1
 ends TwoStFixIRatio_SMCNR_Pin_2
 // Library name: TSMC22ULL_Std_AMP_LIB
 // Cell name: TB_TRANTwoStFixIRatio_SMCNR_Pin_2
 // View name: schematic
 V0 (VDD 0) vsource dc=VDD type=dc
 C0 (SR_VOUT 0) capacitor c=CLOAD
 I1 (0 VDD SR_VOUT SR_VINP SR_VOUT) TwoStFixIRatio_SMCNR_Pin_2
 V1 (SR_VINP 0) vsource dc=0 type=pulse delay=1u edgetype=linear val0=0.1 val1=0.5 period=1 rise=1p fall=1p width=2.34e-05
simulatorOptions options temp=125
 tran tran stop=4.78e-05 errpreset=conservative
 save SR_VOUT SR_VINP
saveOptions options save=selected

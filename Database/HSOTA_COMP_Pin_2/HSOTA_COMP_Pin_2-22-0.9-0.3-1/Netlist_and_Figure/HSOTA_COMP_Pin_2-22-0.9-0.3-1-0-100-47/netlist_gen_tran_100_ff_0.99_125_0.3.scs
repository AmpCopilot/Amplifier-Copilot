 // Design library name: 2025_5_DCDC_TO
 // Design cell name: TB_TRAN_HSOTA_COMP_Pin_2_Pin_2
 simulator lang=spectre
 global 0
 parameters RESISTOR_0=5.0k RESISTOR_2=5.0k MOSFET_0_1_L_LOAD_NMOS=0.344u MOSFET_0_1_M_LOAD_NMOS=30.0 MOSFET_0_1_W_LOAD_NMOS=0.1u MOSFET_10_1_L_gm1_PMOS=0.0914u MOSFET_10_1_M_gm1_PMOS=27.0 MOSFET_10_1_W_gm1_PMOS=0.809u MOSFET_14_1_L_BIASCM_PMOS=0.818u MOSFET_14_1_M_BIASCM_PMOS=13.0 MOSFET_14_1_W_BIASCM_PMOS=0.173u MOSFET_2_1_L_gm2_PMOS=0.129u MOSFET_2_1_M_gm2_PMOS=17.0 MOSFET_2_1_W_gm2_PMOS=0.237u MOSFET_4_1_L_gm3_NMOS=0.424u MOSFET_4_1_M_gm3_NMOS=7.0 MOSFET_4_1_W_gm3_NMOS=0.521u MOSFET_6_1_L_BIASCM_PMOS=0.06u MOSFET_6_1_M_BIASCM_NMOS=11.0 MOSFET_6_1_M_BIASCM_PMOS=10.0 MOSFET_6_1_W_BIASCM_PMOS=0.139u CURRENT_0_BIAS=10.0u CLOAD=1p VCM=0.3 VDD=0.99
 include "/home/soc/zhihc21/7_Amp_complier/FAST_20240508/src/model/spectre_22model/crn22ull_1d8_elk_v1d3_1p1_shrink0d855_embedded_usage.scs" section=ffMacro_MOS_MOSCAP
include "/home/soc/zhihc21/7_Amp_complier/FAST_20240508/src/model/spectre_22model/crn22ull_1d8_elk_v1d3_1p1_shrink0d855_embedded_usage.scs" section=pre_simu
// Library name: 2025_5_DCDC_TO
 // Cell name: HSOTA_COMP_Pin_2
 // View name: schematic
 subckt HSOTA_COMP_Pin_2 GNDA VDDA VINN VINP VOUT
     M0 (net14 net20 GNDA GNDA) nch_ulvt_mac l=MOSFET_0_1_L_LOAD_NMOS w=MOSFET_0_1_W_LOAD_NMOS*1 multi=MOSFET_0_1_M_LOAD_NMOS nf=1
     M20 (VOUT net2 GNDA GNDA) nch_ulvt_mac l=MOSFET_4_1_L_gm3_NMOS w=MOSFET_4_1_W_gm3_NMOS*1 multi=MOSFET_4_1_M_gm3_NMOS nf=1
     M4 (net11 net14 GNDA GNDA) nch_ulvt_mac l=MOSFET_4_1_L_gm3_NMOS w=MOSFET_4_1_W_gm3_NMOS*1 multi=MOSFET_4_1_M_gm3_NMOS nf=1
     M1 (net2 net20 GNDA GNDA) nch_ulvt_mac l=MOSFET_0_1_L_LOAD_NMOS w=MOSFET_0_1_W_LOAD_NMOS*1 multi=MOSFET_0_1_M_LOAD_NMOS nf=1
     R1 (net14 net20) resistor r=RESISTOR_0
     R0 (net20 net2) resistor r=RESISTOR_0
     R2 (net21 GNDA) resistor r=RESISTOR_2
     R3 (GNDA net30) resistor r=RESISTOR_2
     M16 (VOUT net11 VDDA VDDA) pch_ulvt_mac l=MOSFET_14_1_L_BIASCM_PMOS w=MOSFET_14_1_W_BIASCM_PMOS*1 multi=MOSFET_14_1_M_BIASCM_PMOS nf=1
     M14 (net11 net11 VDDA VDDA) pch_ulvt_mac l=MOSFET_14_1_L_BIASCM_PMOS w=MOSFET_14_1_W_BIASCM_PMOS*1 multi=MOSFET_14_1_M_BIASCM_PMOS nf=1
     M12 (net32 net4 VDDA VDDA) pch_ulvt_mac l=MOSFET_6_1_L_BIASCM_PMOS w=MOSFET_6_1_W_BIASCM_PMOS*1 multi=6*MOSFET_6_1_M_BIASCM_NMOS nf=1
     M3 (net2 net30 net32 net32) pch_ulvt_mac l=MOSFET_2_1_L_gm2_PMOS w=MOSFET_2_1_W_gm2_PMOS*1 multi=MOSFET_2_1_M_gm2_PMOS nf=1
     M2 (net14 net21 net32 net32) pch_ulvt_mac l=MOSFET_2_1_L_gm2_PMOS w=MOSFET_2_1_W_gm2_PMOS*1 multi=MOSFET_2_1_M_gm2_PMOS nf=1
     M9 (VDDA net4 VDDA VDDA) pch_ulvt_mac l=150n w=320n multi=1 nf=1
     M8 (VDDA net4 VDDA VDDA) pch_ulvt_mac l=150n w=320n multi=1 nf=1
     M7 (net31 net4 VDDA VDDA) pch_ulvt_mac l=MOSFET_6_1_L_BIASCM_PMOS w=MOSFET_6_1_W_BIASCM_PMOS*1 multi=6*MOSFET_6_1_M_BIASCM_NMOS nf=1
     M6 (net4 net4 VDDA VDDA) pch_ulvt_mac l=MOSFET_6_1_L_BIASCM_PMOS w=MOSFET_6_1_W_BIASCM_PMOS*1 multi=MOSFET_6_1_M_BIASCM_PMOS nf=1
     M11 (net30 VINN net31 net31) pch_ulvt_mac l=MOSFET_10_1_L_gm1_PMOS w=MOSFET_10_1_W_gm1_PMOS*1 multi=MOSFET_10_1_M_gm1_PMOS nf=1
     M10 (net21 VINP net31 net31) pch_ulvt_mac l=MOSFET_10_1_L_gm1_PMOS w=MOSFET_10_1_W_gm1_PMOS*1 multi=MOSFET_10_1_M_gm1_PMOS nf=1
     I0 (net4 GNDA) isource dc=CURRENT_0_BIAS type=dc
 ends HSOTA_COMP_Pin_2
 // Library name: 2025_5_DCDC_TO
 // Cell name: TB_TRAN_HSOTA_COMP_Pin_2_Pin_2
 // View name: schematic
 V0 (VDD 0) vsource dc=VDD type=dc
 C0 (SR_VOUT 0) capacitor c=CLOAD
 I20 (0 VDD SR_VOUT SR_VINP SR_VOUT) HSOTA_COMP_Pin_2
 V1 (SR_VINP 0) vsource dc=0 type=pulse delay=1u edgetype=linear val0=0.2 val1=0.4 period=1 rise=1p fall=1p width=2.69e-05
simulatorOptions options temp=125
 tran tran stop=5.49e-05 errpreset=conservative
 save SR_VOUT SR_VINP
saveOptions options save=selected

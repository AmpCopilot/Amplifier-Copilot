 // Design library name: 2025_5_DCDC_TO
 // Design cell name: TB_TRAN_CLASSAB_NULL_Pin_3
 simulator lang=spectre
 global 0
 parameters MOSFET_0_1_L_BIASCM_NMOS=7.3u MOSFET_0_1_M_BIASCM_NMOS=13.0 MOSFET_0_1_W_BIASCM_NMOS=1.59u MOSFET_10_1_L_gm1_PMOS=14.2u MOSFET_10_1_M_gm1_PMOS=2.0 MOSFET_10_1_W_gm1_PMOS=2.12u MOSFET_12_1_L_gm2_NMOS=4.79u MOSFET_12_1_M_gm2_NMOS=8.0 MOSFET_12_1_W_gm2_NMOS=0.22u MOSFET_13_1_L_BIASCM_NMOS=5.31u MOSFET_13_1_M_BIASCM_NMOS=5.0 MOSFET_13_1_W_BIASCM_NMOS=0.421u MOSFET_14_1_L_BIASCM_PMOS=19.1u MOSFET_14_1_M_BIASCM_PMOS=13.0 MOSFET_14_1_W_BIASCM_PMOS=1.53u MOSFET_15_1_L_BIASCM_PMOS=0.18u MOSFET_15_1_M_BIASCM_PMOS=7.0 MOSFET_15_1_W_BIASCM_PMOS=2.37u MOSFET_18_1_L_BIASCM_PMOS=7.5u MOSFET_18_1_M_BIASCM_PMOS=1.0 MOSFET_18_1_W_BIASCM_PMOS=5.0u MOSFET_21_1_L_BIASCM_NMOS=0.18u MOSFET_21_1_M_BIASCM_NMOS=1.0 MOSFET_21_1_W_BIASCM_NMOS=0.845u MOSFET_22_1_L_BIASCM_PMOS=12.4u MOSFET_22_1_M_BIASCM_PMOS=19.0 MOSFET_22_1_W_BIASCM_PMOS=3.11u MOSFET_28_1_L_gm3_PMOS=10.0u MOSFET_28_1_M_gm3_PMOS=9.0 MOSFET_28_1_W_gm3_PMOS=5.0u MOSFET_29_1_L_gm3_NMOS=0.18u MOSFET_29_1_M_gm3_NMOS=13.0 MOSFET_29_1_W_gm3_NMOS=4.93u MOSFET_4_1_L_LOAD_NMOS=4.26u MOSFET_4_1_M_LOAD_NMOS=12.0 MOSFET_4_1_W_LOAD_NMOS=2.32u MOSFET_6_1_L_BIASCM_PMOS=16.5u MOSFET_6_1_M_BIASCM_NMOS=15.0 RESISTOR_0=34.0k RESISTOR_1=64.0k MOSFET_6_1_M_BIASCM_PMOS=1.0 MOSFET_6_1_W_BIASCM_PMOS=2.37u CURRENT_0_BIAS=7.77u CLOAD=0.1p VCM=0.8 VDD=1.7
 include "/home/soc/zhihc21/7_Amp_complier/FAST_20240508/src/model/c018bcd_gen2_v1d6_usage.scs" section=ss_lib
include "/home/soc/zhihc21/7_Amp_complier/FAST_20240508/src/model/c018bcd_gen2_v1d6_usage.scs" section=pre_simu
// Library name: 2025_5_DCDC_TO
 // Cell name: CLASSAB_NULL_Pin_3
 // View name: schematic
 subckt CLASSAB_NULL_Pin_3 GNDA VDDA VINN VINP VOUT
     M29 (VOUT net13 GNDA GNDA) nch_mac l=MOSFET_29_1_L_gm3_NMOS w=MOSFET_29_1_W_gm3_NMOS*1 multi=MOSFET_29_1_M_gm3_NMOS nf=1
     M27 (net17 net1 GNDA GNDA) nch_mac l=MOSFET_0_1_L_BIASCM_NMOS w=MOSFET_0_1_W_BIASCM_NMOS*1 multi=MOSFET_0_1_M_BIASCM_NMOS*4 nf=1
     M24 (net16 net16 GNDA GNDA) nch_mac l=MOSFET_21_1_L_BIASCM_NMOS w=MOSFET_21_1_W_BIASCM_NMOS*1 multi=MOSFET_21_1_M_BIASCM_NMOS nf=1
     M23 (net15 net15 net16 GNDA) nch_mac l=MOSFET_21_1_L_BIASCM_NMOS w=MOSFET_21_1_W_BIASCM_NMOS*1 multi=MOSFET_21_1_M_BIASCM_NMOS nf=1
     M21 (net12 net15 net13 GNDA) nch_mac l=MOSFET_21_1_L_BIASCM_NMOS w=MOSFET_21_1_W_BIASCM_NMOS*1 multi=MOSFET_21_1_M_BIASCM_NMOS nf=1
     M20 (net14 net5 GNDA GNDA) nch_mac l=MOSFET_12_1_L_gm2_NMOS w=MOSFET_12_1_W_gm2_NMOS*1 multi=MOSFET_12_1_M_gm2_NMOS nf=1
     M19 (net13 net19 net14 GNDA) nch_mac l=MOSFET_13_1_L_BIASCM_NMOS w=MOSFET_13_1_W_BIASCM_NMOS*1 multi=MOSFET_13_1_M_BIASCM_NMOS nf=1
     M13 (net9 net19 net8 GNDA) nch_mac l=MOSFET_13_1_L_BIASCM_NMOS w=MOSFET_13_1_W_BIASCM_NMOS*1 multi=MOSFET_13_1_M_BIASCM_NMOS nf=1
     M12 (net8 net7 GNDA GNDA) nch_mac l=MOSFET_12_1_L_gm2_NMOS w=MOSFET_12_1_W_gm2_NMOS*1 multi=MOSFET_12_1_M_gm2_NMOS nf=1
     M5 (net7 net6 GNDA GNDA) nch_mac l=MOSFET_4_1_L_LOAD_NMOS w=MOSFET_4_1_W_LOAD_NMOS*1 multi=MOSFET_4_1_M_LOAD_NMOS nf=1
     M4 (net5 net6 GNDA GNDA) nch_mac l=MOSFET_4_1_L_LOAD_NMOS w=MOSFET_4_1_W_LOAD_NMOS*1 multi=MOSFET_4_1_M_LOAD_NMOS nf=1
     M1 (net2 net1 GNDA GNDA) nch_mac l=MOSFET_0_1_L_BIASCM_NMOS w=MOSFET_0_1_W_BIASCM_NMOS*1 multi=MOSFET_0_1_M_BIASCM_NMOS nf=1
     M0 (net1 net1 GNDA GNDA) nch_mac l=MOSFET_0_1_L_BIASCM_NMOS w=MOSFET_0_1_W_BIASCM_NMOS*1 multi=MOSFET_0_1_M_BIASCM_NMOS nf=1
     I0 (VDDA net19) isource dc=CURRENT_0_BIAS type=dc
     M28 (VOUT net12 VDDA VDDA) pch_mac l=MOSFET_28_1_L_gm3_PMOS w=MOSFET_28_1_W_gm3_PMOS*1 multi=MOSFET_28_1_M_gm3_PMOS nf=1
     M26 (net17 net17 net18 VDDA) pch_mac l=MOSFET_18_1_L_BIASCM_PMOS w=MOSFET_18_1_W_BIASCM_PMOS*1 multi=MOSFET_18_1_M_BIASCM_PMOS nf=1
     M25 (net18 net18 VDDA VDDA) pch_mac l=MOSFET_18_1_L_BIASCM_PMOS w=MOSFET_18_1_W_BIASCM_PMOS*1 multi=MOSFET_18_1_M_BIASCM_PMOS nf=1
     M22 (net15 net3 VDDA VDDA) pch_mac l=MOSFET_22_1_L_BIASCM_PMOS w=MOSFET_22_1_W_BIASCM_PMOS*1 multi=MOSFET_22_1_M_BIASCM_PMOS nf=1
     M18 (net13 net17 net12 VDDA) pch_mac l=MOSFET_18_1_L_BIASCM_PMOS w=MOSFET_18_1_W_BIASCM_PMOS*1 multi=MOSFET_18_1_M_BIASCM_PMOS nf=1
     M17 (net12 net2 net11 VDDA) pch_mac l=MOSFET_15_1_L_BIASCM_PMOS w=MOSFET_15_1_W_BIASCM_PMOS*1 multi=MOSFET_15_1_M_BIASCM_PMOS nf=1
     M16 (net11 net9 VDDA VDDA) pch_mac l=MOSFET_14_1_L_BIASCM_PMOS w=MOSFET_14_1_W_BIASCM_PMOS*1 multi=MOSFET_14_1_M_BIASCM_PMOS nf=1
     M15 (net9 net2 net10 VDDA) pch_mac l=MOSFET_15_1_L_BIASCM_PMOS w=MOSFET_15_1_W_BIASCM_PMOS*1 multi=MOSFET_15_1_M_BIASCM_PMOS nf=1
     M14 (net10 net9 VDDA VDDA) pch_mac l=MOSFET_14_1_L_BIASCM_PMOS w=MOSFET_14_1_W_BIASCM_PMOS*1 multi=MOSFET_14_1_M_BIASCM_PMOS nf=1
     M11 (net7 VINP net4 net4) pch_mac l=MOSFET_10_1_L_gm1_PMOS w=MOSFET_10_1_W_gm1_PMOS*1 multi=MOSFET_10_1_M_gm1_PMOS nf=1
     M10 (net5 VINN net4 net4) pch_mac l=MOSFET_10_1_L_gm1_PMOS w=MOSFET_10_1_W_gm1_PMOS*1 multi=MOSFET_10_1_M_gm1_PMOS nf=1
     M7 (net4 net3 VDDA VDDA) pch_mac l=MOSFET_6_1_L_BIASCM_PMOS w=MOSFET_6_1_W_BIASCM_PMOS*1 multi=6*MOSFET_6_1_M_BIASCM_NMOS nf=1
     M6 (net3 net3 VDDA VDDA) pch_mac l=MOSFET_6_1_L_BIASCM_PMOS w=MOSFET_6_1_W_BIASCM_PMOS*1 multi=MOSFET_6_1_M_BIASCM_PMOS nf=1
     R2 (net5 net6) resistor r=RESISTOR_1
     R3 (net6 net7) resistor r=RESISTOR_1
     R0 (net19 net1) resistor r=RESISTOR_0
     R1 (net3 net2) resistor r=RESISTOR_0
 ends CLASSAB_NULL_Pin_3
 // Library name: 2025_5_DCDC_TO
 // Cell name: TB_TRAN_CLASSAB_NULL_Pin_3
 // View name: schematic
 V0 (VDD 0) vsource dc=VDD type=dc
 C0 (SR_VOUT 0) capacitor c=CLOAD
 I19 (0 VDD SR_VOUT SR_VINP SR_VOUT) CLASSAB_NULL_Pin_3
 V1 (SR_VINP 0) vsource dc=0 type=pulse delay=1u edgetype=linear val0=0.7 val1=1 period=1 rise=1p fall=1p width=2.25e-03
simulatorOptions options temp=-25
 tran tran stop=4.49e-03
 save SR_VINP SR_VOUT
saveOptions options save=selected
